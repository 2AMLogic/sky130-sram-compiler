* WRITE trip-voltage ladder: full cell (schematic subckt), 33 independent trials in one transient.
* Each trial: preset Q=1 with a full write, idle, then a 2 ns WL pulse with BLB=VDD and
* BL=VDD*k/32; Q is sampled 0.1 ns before the next trial. Write trip voltage = the highest
* BL level that still flipped the cell (Q < VDD/2).
* NEGATIVE CONTROL: every per-instance mismatch sigma x 6 (slope params of the pinned
* open_pdks mismatch.corner files, x mm_scale); nominal parameters and process corner unchanged.
.param mm_scale=6
.param sky130_fd_pr__nfet_01v8__toxe_slope='3.443e-03*mm_scale'
.param sky130_fd_pr__nfet_01v8__voff_slope='0.007*mm_scale'
.param sky130_fd_pr__nfet_01v8__vth0_slope='3.356e-03*mm_scale'
.param sky130_fd_pr__nfet_01v8__vth0_slope1='7.356e-03*mm_scale'
.param sky130_fd_pr__pfet_01v8__toxe_slope='4.443e-03*mm_scale'
.param sky130_fd_pr__pfet_01v8__toxe_slope1='6.443e-03*mm_scale'
.param sky130_fd_pr__pfet_01v8__toxe_slope2='3.443e-03*mm_scale'
.param sky130_fd_pr__pfet_01v8__nfactor_slope='0.1*mm_scale'
.param sky130_fd_pr__pfet_01v8__nfactor_slope1='0.1*mm_scale'
.param sky130_fd_pr__pfet_01v8__voff_slope2='0.007*mm_scale'
.param sky130_fd_pr__pfet_01v8__vth0_slope='5.856e-03*mm_scale'
.param sky130_fd_pr__pfet_01v8__vth0_slope1='7.356e-03*mm_scale'
.param sky130_fd_pr__pfet_01v8__vth0_slope2='4.356e-03*mm_scale'
.include '../../../design/bitcell/netlist/bitcell_6t.spice'
VVDD vdd 0 dc 1.8
VBLF blf 0 PWL(0n 1 0.1n 1 2n 1 2.05n 1 3.95n 1 4n 0 6n 0 6.05n 1 8n 1 8.1n 1 10n 1 10.05n 1 11.95n 1 12n 0.03125 14n 0.03125 14.05n 1 16n 1 16.1n 1 18n 1 18.05n 1 19.95n 1 20n 0.0625 22n 0.0625 22.05n 1 24n 1 24.1n 1 26n 1 26.05n 1 27.95n 1 28n 0.09375 30n 0.09375 30.05n 1 32n 1 32.1n 1 34n 1 34.05n 1 35.95n 1 36n 0.125 38n 0.125 38.05n 1 40n 1 40.1n 1 42n 1 42.05n 1 43.95n 1 44n 0.15625 46n 0.15625 46.05n 1 48n 1 48.1n 1 50n 1 50.05n 1 51.95n 1 52n 0.1875 54n 0.1875 54.05n 1 56n 1 56.1n 1 58n 1 58.05n 1 59.95n 1 60n 0.21875 62n 0.21875 62.05n 1 64n 1 64.1n 1 66n 1 66.05n 1 67.95n 1 68n 0.25 70n 0.25 70.05n 1 72n 1 72.1n 1 74n 1 74.05n 1 75.95n 1 76n 0.28125 78n 0.28125 78.05n 1 80n 1 80.1n 1 82n 1 82.05n 1 83.95n 1 84n 0.3125 86n 0.3125 86.05n 1 88n 1 88.1n 1 90n 1 90.05n 1 91.95n 1 92n 0.34375 94n 0.34375 94.05n 1 96n 1 96.1n 1 98n 1 98.05n 1 99.95n 1 100n 0.375 102n 0.375 102.05n 1 104n 1 104.1n 1 106n 1 106.05n 1 107.95n 1 108n 0.40625 110n 0.40625 110.05n 1 112n 1 112.1n 1 114n 1 114.05n 1 115.95n 1 116n 0.4375 118n 0.4375 118.05n 1 120n 1 120.1n 1 122n 1 122.05n 1 123.95n 1 124n 0.46875 126n 0.46875 126.05n 1 128n 1 128.1n 1 130n 1 130.05n 1 131.95n 1 132n 0.5 134n 0.5 134.05n 1 136n 1 136.1n 1 138n 1 138.05n 1 139.95n 1 140n 0.53125 142n 0.53125 142.05n 1 144n 1 144.1n 1 146n 1 146.05n 1 147.95n 1 148n 0.5625 150n 0.5625 150.05n 1 152n 1 152.1n 1 154n 1 154.05n 1 155.95n 1 156n 0.59375 158n 0.59375 158.05n 1 160n 1 160.1n 1 162n 1 162.05n 1 163.95n 1 164n 0.625 166n 0.625 166.05n 1 168n 1 168.1n 1 170n 1 170.05n 1 171.95n 1 172n 0.65625 174n 0.65625 174.05n 1 176n 1 176.1n 1 178n 1 178.05n 1 179.95n 1 180n 0.6875 182n 0.6875 182.05n 1 184n 1 184.1n 1 186n 1 186.05n 1 187.95n 1 188n 0.71875 190n 0.71875 190.05n 1 192n 1 192.1n 1 194n 1 194.05n 1 195.95n 1 196n 0.75 198n 0.75 198.05n 1 200n 1 200.1n 1 202n 1 202.05n 1 203.95n 1 204n 0.78125 206n 0.78125 206.05n 1 208n 1 208.1n 1 210n 1 210.05n 1 211.95n 1 212n 0.8125 214n 0.8125 214.05n 1 216n 1 216.1n 1 218n 1 218.05n 1 219.95n 1 220n 0.84375 222n 0.84375 222.05n 1 224n 1 224.1n 1 226n 1 226.05n 1 227.95n 1 228n 0.875 230n 0.875 230.05n 1 232n 1 232.1n 1 234n 1 234.05n 1 235.95n 1 236n 0.90625 238n 0.90625 238.05n 1 240n 1 240.1n 1 242n 1 242.05n 1 243.95n 1 244n 0.9375 246n 0.9375 246.05n 1 248n 1 248.1n 1 250n 1 250.05n 1 251.95n 1 252n 0.96875 254n 0.96875 254.05n 1 256n 1 256.1n 1 258n 1 258.05n 1 259.95n 1 260n 1 262n 1 262.05n 1 264n 1)
VBLBF blbf 0 PWL(0n 0 0.1n 0 2n 0 2.05n 1 4n 1 6n 1 8n 1 8.1n 0 10n 0 10.05n 1 12n 1 14n 1 16n 1 16.1n 0 18n 0 18.05n 1 20n 1 22n 1 24n 1 24.1n 0 26n 0 26.05n 1 28n 1 30n 1 32n 1 32.1n 0 34n 0 34.05n 1 36n 1 38n 1 40n 1 40.1n 0 42n 0 42.05n 1 44n 1 46n 1 48n 1 48.1n 0 50n 0 50.05n 1 52n 1 54n 1 56n 1 56.1n 0 58n 0 58.05n 1 60n 1 62n 1 64n 1 64.1n 0 66n 0 66.05n 1 68n 1 70n 1 72n 1 72.1n 0 74n 0 74.05n 1 76n 1 78n 1 80n 1 80.1n 0 82n 0 82.05n 1 84n 1 86n 1 88n 1 88.1n 0 90n 0 90.05n 1 92n 1 94n 1 96n 1 96.1n 0 98n 0 98.05n 1 100n 1 102n 1 104n 1 104.1n 0 106n 0 106.05n 1 108n 1 110n 1 112n 1 112.1n 0 114n 0 114.05n 1 116n 1 118n 1 120n 1 120.1n 0 122n 0 122.05n 1 124n 1 126n 1 128n 1 128.1n 0 130n 0 130.05n 1 132n 1 134n 1 136n 1 136.1n 0 138n 0 138.05n 1 140n 1 142n 1 144n 1 144.1n 0 146n 0 146.05n 1 148n 1 150n 1 152n 1 152.1n 0 154n 0 154.05n 1 156n 1 158n 1 160n 1 160.1n 0 162n 0 162.05n 1 164n 1 166n 1 168n 1 168.1n 0 170n 0 170.05n 1 172n 1 174n 1 176n 1 176.1n 0 178n 0 178.05n 1 180n 1 182n 1 184n 1 184.1n 0 186n 0 186.05n 1 188n 1 190n 1 192n 1 192.1n 0 194n 0 194.05n 1 196n 1 198n 1 200n 1 200.1n 0 202n 0 202.05n 1 204n 1 206n 1 208n 1 208.1n 0 210n 0 210.05n 1 212n 1 214n 1 216n 1 216.1n 0 218n 0 218.05n 1 220n 1 222n 1 224n 1 224.1n 0 226n 0 226.05n 1 228n 1 230n 1 232n 1 232.1n 0 234n 0 234.05n 1 236n 1 238n 1 240n 1 240.1n 0 242n 0 242.05n 1 244n 1 246n 1 248n 1 248.1n 0 250n 0 250.05n 1 252n 1 254n 1 256n 1 256.1n 0 258n 0 258.05n 1 260n 1 262n 1 264n 1)
VWLF wlf 0 PWL(0n 0 0.1n 0 0.15n 1 1.9n 1 1.95n 0 3.975n 0 4.025n 1 5.975n 1 6.025n 0 8n 0 8.1n 0 8.15n 1 9.9n 1 9.95n 0 11.975n 0 12.025n 1 13.975n 1 14.025n 0 16n 0 16.1n 0 16.15n 1 17.9n 1 17.95n 0 19.975n 0 20.025n 1 21.975n 1 22.025n 0 24n 0 24.1n 0 24.15n 1 25.9n 1 25.95n 0 27.975n 0 28.025n 1 29.975n 1 30.025n 0 32n 0 32.1n 0 32.15n 1 33.9n 1 33.95n 0 35.975n 0 36.025n 1 37.975n 1 38.025n 0 40n 0 40.1n 0 40.15n 1 41.9n 1 41.95n 0 43.975n 0 44.025n 1 45.975n 1 46.025n 0 48n 0 48.1n 0 48.15n 1 49.9n 1 49.95n 0 51.975n 0 52.025n 1 53.975n 1 54.025n 0 56n 0 56.1n 0 56.15n 1 57.9n 1 57.95n 0 59.975n 0 60.025n 1 61.975n 1 62.025n 0 64n 0 64.1n 0 64.15n 1 65.9n 1 65.95n 0 67.975n 0 68.025n 1 69.975n 1 70.025n 0 72n 0 72.1n 0 72.15n 1 73.9n 1 73.95n 0 75.975n 0 76.025n 1 77.975n 1 78.025n 0 80n 0 80.1n 0 80.15n 1 81.9n 1 81.95n 0 83.975n 0 84.025n 1 85.975n 1 86.025n 0 88n 0 88.1n 0 88.15n 1 89.9n 1 89.95n 0 91.975n 0 92.025n 1 93.975n 1 94.025n 0 96n 0 96.1n 0 96.15n 1 97.9n 1 97.95n 0 99.975n 0 100.025n 1 101.975n 1 102.025n 0 104n 0 104.1n 0 104.15n 1 105.9n 1 105.95n 0 107.975n 0 108.025n 1 109.975n 1 110.025n 0 112n 0 112.1n 0 112.15n 1 113.9n 1 113.95n 0 115.975n 0 116.025n 1 117.975n 1 118.025n 0 120n 0 120.1n 0 120.15n 1 121.9n 1 121.95n 0 123.975n 0 124.025n 1 125.975n 1 126.025n 0 128n 0 128.1n 0 128.15n 1 129.9n 1 129.95n 0 131.975n 0 132.025n 1 133.975n 1 134.025n 0 136n 0 136.1n 0 136.15n 1 137.9n 1 137.95n 0 139.975n 0 140.025n 1 141.975n 1 142.025n 0 144n 0 144.1n 0 144.15n 1 145.9n 1 145.95n 0 147.975n 0 148.025n 1 149.975n 1 150.025n 0 152n 0 152.1n 0 152.15n 1 153.9n 1 153.95n 0 155.975n 0 156.025n 1 157.975n 1 158.025n 0 160n 0 160.1n 0 160.15n 1 161.9n 1 161.95n 0 163.975n 0 164.025n 1 165.975n 1 166.025n 0 168n 0 168.1n 0 168.15n 1 169.9n 1 169.95n 0 171.975n 0 172.025n 1 173.975n 1 174.025n 0 176n 0 176.1n 0 176.15n 1 177.9n 1 177.95n 0 179.975n 0 180.025n 1 181.975n 1 182.025n 0 184n 0 184.1n 0 184.15n 1 185.9n 1 185.95n 0 187.975n 0 188.025n 1 189.975n 1 190.025n 0 192n 0 192.1n 0 192.15n 1 193.9n 1 193.95n 0 195.975n 0 196.025n 1 197.975n 1 198.025n 0 200n 0 200.1n 0 200.15n 1 201.9n 1 201.95n 0 203.975n 0 204.025n 1 205.975n 1 206.025n 0 208n 0 208.1n 0 208.15n 1 209.9n 1 209.95n 0 211.975n 0 212.025n 1 213.975n 1 214.025n 0 216n 0 216.1n 0 216.15n 1 217.9n 1 217.95n 0 219.975n 0 220.025n 1 221.975n 1 222.025n 0 224n 0 224.1n 0 224.15n 1 225.9n 1 225.95n 0 227.975n 0 228.025n 1 229.975n 1 230.025n 0 232n 0 232.1n 0 232.15n 1 233.9n 1 233.95n 0 235.975n 0 236.025n 1 237.975n 1 238.025n 0 240n 0 240.1n 0 240.15n 1 241.9n 1 241.95n 0 243.975n 0 244.025n 1 245.975n 1 246.025n 0 248n 0 248.1n 0 248.15n 1 249.9n 1 249.95n 0 251.975n 0 252.025n 1 253.975n 1 254.025n 0 256n 0 256.1n 0 256.15n 1 257.9n 1 257.95n 0 259.975n 0 260.025n 1 261.975n 1 262.025n 0 264n 0)
BBL bl 0 V='v(blf)*v(vdd)'
BBLB blb 0 V='v(blbf)*v(vdd)'
BWL wl 0 V='v(wlf)*v(vdd)'
XDUT bl blb wl vdd 0 bitcell_6t
