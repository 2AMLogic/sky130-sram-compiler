** sram_256x32_m4: words=256 bits=32 mux=4 rows=64 cols=128
** generated by design/compiler/sram_compile.py; do not edit by hand
.subckt bitcell_6t BL BLB WL VDD VSS
*.iopin BL
*.iopin BLB
*.iopin WL
*.iopin VDD
*.iopin VSS
XMPL Q QB VDD VDD sky130_fd_pr__pfet_01v8 L=0.15 W=0.42 nf=1 ad=0.1218 as=0.1218 pd=1.42 ps=1.42 nrd=0.6905 nrs=0.6905 sa=0 sb=0 sd=0 mult=1 m=1
XMPR QB Q VDD VDD sky130_fd_pr__pfet_01v8 L=0.15 W=0.42 nf=1 ad=0.1218 as=0.1218 pd=1.42 ps=1.42 nrd=0.6905 nrs=0.6905 sa=0 sb=0 sd=0 mult=1 m=1
XMNL Q QB VSS VSS sky130_fd_pr__nfet_01v8 L=0.15 W=0.84 nf=1 ad=0.2436 as=0.2436 pd=2.26 ps=2.26 nrd=0.3452 nrs=0.3452 sa=0 sb=0 sd=0 mult=1 m=1
XMNR QB Q VSS VSS sky130_fd_pr__nfet_01v8 L=0.15 W=0.84 nf=1 ad=0.2436 as=0.2436 pd=2.26 ps=2.26 nrd=0.3452 nrs=0.3452 sa=0 sb=0 sd=0 mult=1 m=1
XMAL BL WL Q VSS sky130_fd_pr__nfet_01v8 L=0.15 W=0.42 nf=1 ad=0.1218 as=0.1218 pd=1.42 ps=1.42 nrd=0.6905 nrs=0.6905 sa=0 sb=0 sd=0 mult=1 m=1
XMAR BLB WL QB VSS sky130_fd_pr__nfet_01v8 L=0.15 W=0.42 nf=1 ad=0.1218 as=0.1218 pd=1.42 ps=1.42 nrd=0.6905 nrs=0.6905 sa=0 sb=0 sd=0 mult=1 m=1
.ends
.subckt sram_colmux BL BLB SBL SBLB SEL VSS
*.iopin BL
*.iopin BLB
*.iopin SBL
*.iopin SBLB
*.iopin SEL
*.iopin VSS
XMN1 SBL SEL BL VSS sky130_fd_pr__nfet_01v8 L=0.15 W=0.84 nf=1 ad=0.2436 as=0.2436 pd=2.26 ps=2.26 nrd=0.3452 nrs=0.3452 sa=0 sb=0 sd=0 mult=1 m=1
XMN2 SBLB SEL BLB VSS sky130_fd_pr__nfet_01v8 L=0.15 W=0.84 nf=1 ad=0.2436 as=0.2436 pd=2.26 ps=2.26 nrd=0.3452 nrs=0.3452 sa=0 sb=0 sd=0 mult=1 m=1
.ends
.subckt sram_inv A Y VDD VSS
*.iopin A
*.iopin Y
*.iopin VDD
*.iopin VSS
XMP Y A VDD VDD sky130_fd_pr__pfet_01v8 L=0.15 W=0.84 nf=1 ad=0.2436 as=0.2436 pd=2.26 ps=2.26 nrd=0.3452 nrs=0.3452 sa=0 sb=0 sd=0 mult=1 m=1
XMN Y A VSS VSS sky130_fd_pr__nfet_01v8 L=0.15 W=0.42 nf=1 ad=0.1218 as=0.1218 pd=1.42 ps=1.42 nrd=0.6905 nrs=0.6905 sa=0 sb=0 sd=0 mult=1 m=1
.ends
.subckt sram_nand2 A0 A1 Y VDD VSS
*.iopin A0
*.iopin A1
*.iopin Y
*.iopin VDD
*.iopin VSS
XMP0 Y A0 VDD VDD sky130_fd_pr__pfet_01v8 L=0.15 W=0.84 nf=1 ad=0.2436 as=0.2436 pd=2.26 ps=2.26 nrd=0.3452 nrs=0.3452 sa=0 sb=0 sd=0 mult=1 m=1
XMP1 Y A1 VDD VDD sky130_fd_pr__pfet_01v8 L=0.15 W=0.84 nf=1 ad=0.2436 as=0.2436 pd=2.26 ps=2.26 nrd=0.3452 nrs=0.3452 sa=0 sb=0 sd=0 mult=1 m=1
XMN0 Y A0 N1 VSS sky130_fd_pr__nfet_01v8 L=0.15 W=0.84 nf=1 ad=0.2436 as=0.2436 pd=2.26 ps=2.26 nrd=0.3452 nrs=0.3452 sa=0 sb=0 sd=0 mult=1 m=1
XMN1 N1 A1 VSS VSS sky130_fd_pr__nfet_01v8 L=0.15 W=0.84 nf=1 ad=0.2436 as=0.2436 pd=2.26 ps=2.26 nrd=0.3452 nrs=0.3452 sa=0 sb=0 sd=0 mult=1 m=1
.ends
.subckt sram_nand3 A0 A1 A2 Y VDD VSS
*.iopin A0
*.iopin A1
*.iopin A2
*.iopin Y
*.iopin VDD
*.iopin VSS
XMP0 Y A0 VDD VDD sky130_fd_pr__pfet_01v8 L=0.15 W=0.84 nf=1 ad=0.2436 as=0.2436 pd=2.26 ps=2.26 nrd=0.3452 nrs=0.3452 sa=0 sb=0 sd=0 mult=1 m=1
XMP1 Y A1 VDD VDD sky130_fd_pr__pfet_01v8 L=0.15 W=0.84 nf=1 ad=0.2436 as=0.2436 pd=2.26 ps=2.26 nrd=0.3452 nrs=0.3452 sa=0 sb=0 sd=0 mult=1 m=1
XMP2 Y A2 VDD VDD sky130_fd_pr__pfet_01v8 L=0.15 W=0.84 nf=1 ad=0.2436 as=0.2436 pd=2.26 ps=2.26 nrd=0.3452 nrs=0.3452 sa=0 sb=0 sd=0 mult=1 m=1
XMN0 Y A0 N1 VSS sky130_fd_pr__nfet_01v8 L=0.15 W=1.26 nf=1 ad=0.3654 as=0.3654 pd=3.1 ps=3.1 nrd=0.2302 nrs=0.2302 sa=0 sb=0 sd=0 mult=1 m=1
XMN1 N1 A1 N2 VSS sky130_fd_pr__nfet_01v8 L=0.15 W=1.26 nf=1 ad=0.3654 as=0.3654 pd=3.1 ps=3.1 nrd=0.2302 nrs=0.2302 sa=0 sb=0 sd=0 mult=1 m=1
XMN2 N2 A2 VSS VSS sky130_fd_pr__nfet_01v8 L=0.15 W=1.26 nf=1 ad=0.3654 as=0.3654 pd=3.1 ps=3.1 nrd=0.2302 nrs=0.2302 sa=0 sb=0 sd=0 mult=1 m=1
.ends
.subckt sram_nand4 A0 A1 A2 A3 Y VDD VSS
*.iopin A0
*.iopin A1
*.iopin A2
*.iopin A3
*.iopin Y
*.iopin VDD
*.iopin VSS
XMP0 Y A0 VDD VDD sky130_fd_pr__pfet_01v8 L=0.15 W=0.84 nf=1 ad=0.2436 as=0.2436 pd=2.26 ps=2.26 nrd=0.3452 nrs=0.3452 sa=0 sb=0 sd=0 mult=1 m=1
XMP1 Y A1 VDD VDD sky130_fd_pr__pfet_01v8 L=0.15 W=0.84 nf=1 ad=0.2436 as=0.2436 pd=2.26 ps=2.26 nrd=0.3452 nrs=0.3452 sa=0 sb=0 sd=0 mult=1 m=1
XMP2 Y A2 VDD VDD sky130_fd_pr__pfet_01v8 L=0.15 W=0.84 nf=1 ad=0.2436 as=0.2436 pd=2.26 ps=2.26 nrd=0.3452 nrs=0.3452 sa=0 sb=0 sd=0 mult=1 m=1
XMP3 Y A3 VDD VDD sky130_fd_pr__pfet_01v8 L=0.15 W=0.84 nf=1 ad=0.2436 as=0.2436 pd=2.26 ps=2.26 nrd=0.3452 nrs=0.3452 sa=0 sb=0 sd=0 mult=1 m=1
XMN0 Y A0 N1 VSS sky130_fd_pr__nfet_01v8 L=0.15 W=1.68 nf=1 ad=0.4872 as=0.4872 pd=3.94 ps=3.94 nrd=0.1726 nrs=0.1726 sa=0 sb=0 sd=0 mult=1 m=1
XMN1 N1 A1 N2 VSS sky130_fd_pr__nfet_01v8 L=0.15 W=1.68 nf=1 ad=0.4872 as=0.4872 pd=3.94 ps=3.94 nrd=0.1726 nrs=0.1726 sa=0 sb=0 sd=0 mult=1 m=1
XMN2 N2 A2 N3 VSS sky130_fd_pr__nfet_01v8 L=0.15 W=1.68 nf=1 ad=0.4872 as=0.4872 pd=3.94 ps=3.94 nrd=0.1726 nrs=0.1726 sa=0 sb=0 sd=0 mult=1 m=1
XMN3 N3 A3 VSS VSS sky130_fd_pr__nfet_01v8 L=0.15 W=1.68 nf=1 ad=0.4872 as=0.4872 pd=3.94 ps=3.94 nrd=0.1726 nrs=0.1726 sa=0 sb=0 sd=0 mult=1 m=1
.ends
.subckt sram_precharge BL BLB PCHB VDD
*.iopin BL
*.iopin BLB
*.iopin PCHB
*.iopin VDD
XMP1 BL PCHB VDD VDD sky130_fd_pr__pfet_01v8 L=0.15 W=0.84 nf=1 ad=0.2436 as=0.2436 pd=2.26 ps=2.26 nrd=0.3452 nrs=0.3452 sa=0 sb=0 sd=0 mult=1 m=1
XMP2 BLB PCHB VDD VDD sky130_fd_pr__pfet_01v8 L=0.15 W=0.84 nf=1 ad=0.2436 as=0.2436 pd=2.26 ps=2.26 nrd=0.3452 nrs=0.3452 sa=0 sb=0 sd=0 mult=1 m=1
XMEQ BL PCHB BLB VDD sky130_fd_pr__pfet_01v8 L=0.15 W=0.42 nf=1 ad=0.1218 as=0.1218 pd=1.42 ps=1.42 nrd=0.6905 nrs=0.6905 sa=0 sb=0 sd=0 mult=1 m=1
.ends
.subckt sram_senseamp SBL SBLB SAE SAEB DOUT VDD VSS
*.iopin SBL
*.iopin SBLB
*.iopin SAE
*.iopin SAEB
*.iopin DOUT
*.iopin VDD
*.iopin VSS
XMIL SAN SAEB SBL VSS sky130_fd_pr__nfet_01v8 L=0.15 W=0.84 nf=1 ad=0.2436 as=0.2436 pd=2.26 ps=2.26 nrd=0.3452 nrs=0.3452 sa=0 sb=0 sd=0 mult=1 m=1
XMIR SANB SAEB SBLB VSS sky130_fd_pr__nfet_01v8 L=0.15 W=0.84 nf=1 ad=0.2436 as=0.2436 pd=2.26 ps=2.26 nrd=0.3452 nrs=0.3452 sa=0 sb=0 sd=0 mult=1 m=1
XMPL SAN SANB VDD VDD sky130_fd_pr__pfet_01v8 L=0.15 W=0.84 nf=1 ad=0.2436 as=0.2436 pd=2.26 ps=2.26 nrd=0.3452 nrs=0.3452 sa=0 sb=0 sd=0 mult=1 m=1
XMPR SANB SAN VDD VDD sky130_fd_pr__pfet_01v8 L=0.15 W=0.84 nf=1 ad=0.2436 as=0.2436 pd=2.26 ps=2.26 nrd=0.3452 nrs=0.3452 sa=0 sb=0 sd=0 mult=1 m=1
XMNL SAN SANB TAIL VSS sky130_fd_pr__nfet_01v8 L=0.15 W=0.84 nf=1 ad=0.2436 as=0.2436 pd=2.26 ps=2.26 nrd=0.3452 nrs=0.3452 sa=0 sb=0 sd=0 mult=1 m=1
XMNR SANB SAN TAIL VSS sky130_fd_pr__nfet_01v8 L=0.15 W=0.84 nf=1 ad=0.2436 as=0.2436 pd=2.26 ps=2.26 nrd=0.3452 nrs=0.3452 sa=0 sb=0 sd=0 mult=1 m=1
XMT TAIL SAE VSS VSS sky130_fd_pr__nfet_01v8 L=0.15 W=1.68 nf=1 ad=0.4872 as=0.4872 pd=3.94 ps=3.94 nrd=0.1726 nrs=0.1726 sa=0 sb=0 sd=0 mult=1 m=1
XMOP DOUT SANB VDD VDD sky130_fd_pr__pfet_01v8 L=0.15 W=0.84 nf=1 ad=0.2436 as=0.2436 pd=2.26 ps=2.26 nrd=0.3452 nrs=0.3452 sa=0 sb=0 sd=0 mult=1 m=1
XMON DOUT SANB VSS VSS sky130_fd_pr__nfet_01v8 L=0.15 W=0.42 nf=1 ad=0.1218 as=0.1218 pd=1.42 ps=1.42 nrd=0.6905 nrs=0.6905 sa=0 sb=0 sd=0 mult=1 m=1
.ends
.subckt sram_wdrv SBL SBLB DIN WEN VDD VSS
*.iopin SBL
*.iopin SBLB
*.iopin DIN
*.iopin WEN
*.iopin VDD
*.iopin VSS
XMIP DINB DIN VDD VDD sky130_fd_pr__pfet_01v8 L=0.15 W=0.84 nf=1 ad=0.2436 as=0.2436 pd=2.26 ps=2.26 nrd=0.3452 nrs=0.3452 sa=0 sb=0 sd=0 mult=1 m=1
XMIN DINB DIN VSS VSS sky130_fd_pr__nfet_01v8 L=0.15 W=0.42 nf=1 ad=0.1218 as=0.1218 pd=1.42 ps=1.42 nrd=0.6905 nrs=0.6905 sa=0 sb=0 sd=0 mult=1 m=1
XMW1 SBL DINB X1 VSS sky130_fd_pr__nfet_01v8 L=0.15 W=1.26 nf=1 ad=0.3654 as=0.3654 pd=3.1 ps=3.1 nrd=0.2302 nrs=0.2302 sa=0 sb=0 sd=0 mult=1 m=1
XMW2 X1 WEN VSS VSS sky130_fd_pr__nfet_01v8 L=0.15 W=1.26 nf=1 ad=0.3654 as=0.3654 pd=3.1 ps=3.1 nrd=0.2302 nrs=0.2302 sa=0 sb=0 sd=0 mult=1 m=1
XMW3 SBLB DIN X2 VSS sky130_fd_pr__nfet_01v8 L=0.15 W=1.26 nf=1 ad=0.3654 as=0.3654 pd=3.1 ps=3.1 nrd=0.2302 nrs=0.2302 sa=0 sb=0 sd=0 mult=1 m=1
XMW4 X2 WEN VSS VSS sky130_fd_pr__nfet_01v8 L=0.15 W=1.26 nf=1 ad=0.3654 as=0.3654 pd=3.1 ps=3.1 nrd=0.2302 nrs=0.2302 sa=0 sb=0 sd=0 mult=1 m=1
.ends
.subckt sram_wldrv A Y VDD VSS
*.iopin A
*.iopin Y
*.iopin VDD
*.iopin VSS
XMP Y A VDD VDD sky130_fd_pr__pfet_01v8 L=0.15 W=3.36 nf=1 ad=0.9744 as=0.9744 pd=7.3 ps=7.3 nrd=0.08631 nrs=0.08631 sa=0 sb=0 sd=0 mult=1 m=1
XMN Y A VSS VSS sky130_fd_pr__nfet_01v8 L=0.15 W=1.68 nf=1 ad=0.4872 as=0.4872 pd=3.94 ps=3.94 nrd=0.1726 nrs=0.1726 sa=0 sb=0 sd=0 mult=1 m=1
.ends
.subckt sram_256x32_m4 A0 A1 A2 A3 A4 A5 A6 A7 D0 D1 D2 D3 D4 D5 D6 D7 D8 D9 D10 D11 D12 D13 D14 D15 D16 D17 D18 D19 D20 D21 D22 D23 D24 D25 D26 D27 D28 D29 D30 D31 Q0 Q1 Q2 Q3 Q4 Q5 Q6 Q7 Q8 Q9 Q10 Q11 Q12 Q13 Q14 Q15 Q16 Q17 Q18 Q19 Q20 Q21 Q22 Q23 Q24 Q25 Q26 Q27 Q28 Q29 Q30 Q31 WLEN PCHB SAE WEN VDD VSS
X1_inv A0 A0B VDD VSS sram_inv
X2_inv A1 A1B VDD VSS sram_inv
X3_inv A2 A2B VDD VSS sram_inv
X4_inv A3 A3B VDD VSS sram_inv
X5_inv A4 A4B VDD VSS sram_inv
X6_inv A5 A5B VDD VSS sram_inv
X7_inv A6 A6B VDD VSS sram_inv
X8_inv A7 A7B VDD VSS sram_inv
X9_inv SAE SAEB VDD VSS sram_inv
X10_nand2 A0B A1B CS0_b VDD VSS sram_nand2
X11_inv CS0_b CS0 VDD VSS sram_inv
X12_nand2 A0 A1B CS1_b VDD VSS sram_nand2
X13_inv CS1_b CS1 VDD VSS sram_inv
X14_nand2 A0B A1 CS2_b VDD VSS sram_nand2
X15_inv CS2_b CS2 VDD VSS sram_inv
X16_nand2 A0 A1 CS3_b VDD VSS sram_nand2
X17_inv CS3_b CS3 VDD VSS sram_inv
X18_nand4 A2B A3B A4B WLEN PD0_0_b VDD VSS sram_nand4
X19_inv PD0_0_b PD0_0 VDD VSS sram_inv
X20_nand4 A2 A3B A4B WLEN PD0_1_b VDD VSS sram_nand4
X21_inv PD0_1_b PD0_1 VDD VSS sram_inv
X22_nand4 A2B A3 A4B WLEN PD0_2_b VDD VSS sram_nand4
X23_inv PD0_2_b PD0_2 VDD VSS sram_inv
X24_nand4 A2 A3 A4B WLEN PD0_3_b VDD VSS sram_nand4
X25_inv PD0_3_b PD0_3 VDD VSS sram_inv
X26_nand4 A2B A3B A4 WLEN PD0_4_b VDD VSS sram_nand4
X27_inv PD0_4_b PD0_4 VDD VSS sram_inv
X28_nand4 A2 A3B A4 WLEN PD0_5_b VDD VSS sram_nand4
X29_inv PD0_5_b PD0_5 VDD VSS sram_inv
X30_nand4 A2B A3 A4 WLEN PD0_6_b VDD VSS sram_nand4
X31_inv PD0_6_b PD0_6 VDD VSS sram_inv
X32_nand4 A2 A3 A4 WLEN PD0_7_b VDD VSS sram_nand4
X33_inv PD0_7_b PD0_7 VDD VSS sram_inv
X34_nand3 A5B A6B A7B PD1_0_b VDD VSS sram_nand3
X35_inv PD1_0_b PD1_0 VDD VSS sram_inv
X36_nand3 A5 A6B A7B PD1_1_b VDD VSS sram_nand3
X37_inv PD1_1_b PD1_1 VDD VSS sram_inv
X38_nand3 A5B A6 A7B PD1_2_b VDD VSS sram_nand3
X39_inv PD1_2_b PD1_2 VDD VSS sram_inv
X40_nand3 A5 A6 A7B PD1_3_b VDD VSS sram_nand3
X41_inv PD1_3_b PD1_3 VDD VSS sram_inv
X42_nand3 A5B A6B A7 PD1_4_b VDD VSS sram_nand3
X43_inv PD1_4_b PD1_4 VDD VSS sram_inv
X44_nand3 A5 A6B A7 PD1_5_b VDD VSS sram_nand3
X45_inv PD1_5_b PD1_5 VDD VSS sram_inv
X46_nand3 A5B A6 A7 PD1_6_b VDD VSS sram_nand3
X47_inv PD1_6_b PD1_6 VDD VSS sram_inv
X48_nand3 A5 A6 A7 PD1_7_b VDD VSS sram_nand3
X49_inv PD1_7_b PD1_7 VDD VSS sram_inv
X50_nand2 PD0_0 PD1_0 RWLB0 VDD VSS sram_nand2
X51_wldrv RWLB0 WL0 VDD VSS sram_wldrv
X52_nand2 PD0_1 PD1_0 RWLB1 VDD VSS sram_nand2
X53_wldrv RWLB1 WL1 VDD VSS sram_wldrv
X54_nand2 PD0_2 PD1_0 RWLB2 VDD VSS sram_nand2
X55_wldrv RWLB2 WL2 VDD VSS sram_wldrv
X56_nand2 PD0_3 PD1_0 RWLB3 VDD VSS sram_nand2
X57_wldrv RWLB3 WL3 VDD VSS sram_wldrv
X58_nand2 PD0_4 PD1_0 RWLB4 VDD VSS sram_nand2
X59_wldrv RWLB4 WL4 VDD VSS sram_wldrv
X60_nand2 PD0_5 PD1_0 RWLB5 VDD VSS sram_nand2
X61_wldrv RWLB5 WL5 VDD VSS sram_wldrv
X62_nand2 PD0_6 PD1_0 RWLB6 VDD VSS sram_nand2
X63_wldrv RWLB6 WL6 VDD VSS sram_wldrv
X64_nand2 PD0_7 PD1_0 RWLB7 VDD VSS sram_nand2
X65_wldrv RWLB7 WL7 VDD VSS sram_wldrv
X66_nand2 PD0_0 PD1_1 RWLB8 VDD VSS sram_nand2
X67_wldrv RWLB8 WL8 VDD VSS sram_wldrv
X68_nand2 PD0_1 PD1_1 RWLB9 VDD VSS sram_nand2
X69_wldrv RWLB9 WL9 VDD VSS sram_wldrv
X70_nand2 PD0_2 PD1_1 RWLB10 VDD VSS sram_nand2
X71_wldrv RWLB10 WL10 VDD VSS sram_wldrv
X72_nand2 PD0_3 PD1_1 RWLB11 VDD VSS sram_nand2
X73_wldrv RWLB11 WL11 VDD VSS sram_wldrv
X74_nand2 PD0_4 PD1_1 RWLB12 VDD VSS sram_nand2
X75_wldrv RWLB12 WL12 VDD VSS sram_wldrv
X76_nand2 PD0_5 PD1_1 RWLB13 VDD VSS sram_nand2
X77_wldrv RWLB13 WL13 VDD VSS sram_wldrv
X78_nand2 PD0_6 PD1_1 RWLB14 VDD VSS sram_nand2
X79_wldrv RWLB14 WL14 VDD VSS sram_wldrv
X80_nand2 PD0_7 PD1_1 RWLB15 VDD VSS sram_nand2
X81_wldrv RWLB15 WL15 VDD VSS sram_wldrv
X82_nand2 PD0_0 PD1_2 RWLB16 VDD VSS sram_nand2
X83_wldrv RWLB16 WL16 VDD VSS sram_wldrv
X84_nand2 PD0_1 PD1_2 RWLB17 VDD VSS sram_nand2
X85_wldrv RWLB17 WL17 VDD VSS sram_wldrv
X86_nand2 PD0_2 PD1_2 RWLB18 VDD VSS sram_nand2
X87_wldrv RWLB18 WL18 VDD VSS sram_wldrv
X88_nand2 PD0_3 PD1_2 RWLB19 VDD VSS sram_nand2
X89_wldrv RWLB19 WL19 VDD VSS sram_wldrv
X90_nand2 PD0_4 PD1_2 RWLB20 VDD VSS sram_nand2
X91_wldrv RWLB20 WL20 VDD VSS sram_wldrv
X92_nand2 PD0_5 PD1_2 RWLB21 VDD VSS sram_nand2
X93_wldrv RWLB21 WL21 VDD VSS sram_wldrv
X94_nand2 PD0_6 PD1_2 RWLB22 VDD VSS sram_nand2
X95_wldrv RWLB22 WL22 VDD VSS sram_wldrv
X96_nand2 PD0_7 PD1_2 RWLB23 VDD VSS sram_nand2
X97_wldrv RWLB23 WL23 VDD VSS sram_wldrv
X98_nand2 PD0_0 PD1_3 RWLB24 VDD VSS sram_nand2
X99_wldrv RWLB24 WL24 VDD VSS sram_wldrv
X100_nand2 PD0_1 PD1_3 RWLB25 VDD VSS sram_nand2
X101_wldrv RWLB25 WL25 VDD VSS sram_wldrv
X102_nand2 PD0_2 PD1_3 RWLB26 VDD VSS sram_nand2
X103_wldrv RWLB26 WL26 VDD VSS sram_wldrv
X104_nand2 PD0_3 PD1_3 RWLB27 VDD VSS sram_nand2
X105_wldrv RWLB27 WL27 VDD VSS sram_wldrv
X106_nand2 PD0_4 PD1_3 RWLB28 VDD VSS sram_nand2
X107_wldrv RWLB28 WL28 VDD VSS sram_wldrv
X108_nand2 PD0_5 PD1_3 RWLB29 VDD VSS sram_nand2
X109_wldrv RWLB29 WL29 VDD VSS sram_wldrv
X110_nand2 PD0_6 PD1_3 RWLB30 VDD VSS sram_nand2
X111_wldrv RWLB30 WL30 VDD VSS sram_wldrv
X112_nand2 PD0_7 PD1_3 RWLB31 VDD VSS sram_nand2
X113_wldrv RWLB31 WL31 VDD VSS sram_wldrv
X114_nand2 PD0_0 PD1_4 RWLB32 VDD VSS sram_nand2
X115_wldrv RWLB32 WL32 VDD VSS sram_wldrv
X116_nand2 PD0_1 PD1_4 RWLB33 VDD VSS sram_nand2
X117_wldrv RWLB33 WL33 VDD VSS sram_wldrv
X118_nand2 PD0_2 PD1_4 RWLB34 VDD VSS sram_nand2
X119_wldrv RWLB34 WL34 VDD VSS sram_wldrv
X120_nand2 PD0_3 PD1_4 RWLB35 VDD VSS sram_nand2
X121_wldrv RWLB35 WL35 VDD VSS sram_wldrv
X122_nand2 PD0_4 PD1_4 RWLB36 VDD VSS sram_nand2
X123_wldrv RWLB36 WL36 VDD VSS sram_wldrv
X124_nand2 PD0_5 PD1_4 RWLB37 VDD VSS sram_nand2
X125_wldrv RWLB37 WL37 VDD VSS sram_wldrv
X126_nand2 PD0_6 PD1_4 RWLB38 VDD VSS sram_nand2
X127_wldrv RWLB38 WL38 VDD VSS sram_wldrv
X128_nand2 PD0_7 PD1_4 RWLB39 VDD VSS sram_nand2
X129_wldrv RWLB39 WL39 VDD VSS sram_wldrv
X130_nand2 PD0_0 PD1_5 RWLB40 VDD VSS sram_nand2
X131_wldrv RWLB40 WL40 VDD VSS sram_wldrv
X132_nand2 PD0_1 PD1_5 RWLB41 VDD VSS sram_nand2
X133_wldrv RWLB41 WL41 VDD VSS sram_wldrv
X134_nand2 PD0_2 PD1_5 RWLB42 VDD VSS sram_nand2
X135_wldrv RWLB42 WL42 VDD VSS sram_wldrv
X136_nand2 PD0_3 PD1_5 RWLB43 VDD VSS sram_nand2
X137_wldrv RWLB43 WL43 VDD VSS sram_wldrv
X138_nand2 PD0_4 PD1_5 RWLB44 VDD VSS sram_nand2
X139_wldrv RWLB44 WL44 VDD VSS sram_wldrv
X140_nand2 PD0_5 PD1_5 RWLB45 VDD VSS sram_nand2
X141_wldrv RWLB45 WL45 VDD VSS sram_wldrv
X142_nand2 PD0_6 PD1_5 RWLB46 VDD VSS sram_nand2
X143_wldrv RWLB46 WL46 VDD VSS sram_wldrv
X144_nand2 PD0_7 PD1_5 RWLB47 VDD VSS sram_nand2
X145_wldrv RWLB47 WL47 VDD VSS sram_wldrv
X146_nand2 PD0_0 PD1_6 RWLB48 VDD VSS sram_nand2
X147_wldrv RWLB48 WL48 VDD VSS sram_wldrv
X148_nand2 PD0_1 PD1_6 RWLB49 VDD VSS sram_nand2
X149_wldrv RWLB49 WL49 VDD VSS sram_wldrv
X150_nand2 PD0_2 PD1_6 RWLB50 VDD VSS sram_nand2
X151_wldrv RWLB50 WL50 VDD VSS sram_wldrv
X152_nand2 PD0_3 PD1_6 RWLB51 VDD VSS sram_nand2
X153_wldrv RWLB51 WL51 VDD VSS sram_wldrv
X154_nand2 PD0_4 PD1_6 RWLB52 VDD VSS sram_nand2
X155_wldrv RWLB52 WL52 VDD VSS sram_wldrv
X156_nand2 PD0_5 PD1_6 RWLB53 VDD VSS sram_nand2
X157_wldrv RWLB53 WL53 VDD VSS sram_wldrv
X158_nand2 PD0_6 PD1_6 RWLB54 VDD VSS sram_nand2
X159_wldrv RWLB54 WL54 VDD VSS sram_wldrv
X160_nand2 PD0_7 PD1_6 RWLB55 VDD VSS sram_nand2
X161_wldrv RWLB55 WL55 VDD VSS sram_wldrv
X162_nand2 PD0_0 PD1_7 RWLB56 VDD VSS sram_nand2
X163_wldrv RWLB56 WL56 VDD VSS sram_wldrv
X164_nand2 PD0_1 PD1_7 RWLB57 VDD VSS sram_nand2
X165_wldrv RWLB57 WL57 VDD VSS sram_wldrv
X166_nand2 PD0_2 PD1_7 RWLB58 VDD VSS sram_nand2
X167_wldrv RWLB58 WL58 VDD VSS sram_wldrv
X168_nand2 PD0_3 PD1_7 RWLB59 VDD VSS sram_nand2
X169_wldrv RWLB59 WL59 VDD VSS sram_wldrv
X170_nand2 PD0_4 PD1_7 RWLB60 VDD VSS sram_nand2
X171_wldrv RWLB60 WL60 VDD VSS sram_wldrv
X172_nand2 PD0_5 PD1_7 RWLB61 VDD VSS sram_nand2
X173_wldrv RWLB61 WL61 VDD VSS sram_wldrv
X174_nand2 PD0_6 PD1_7 RWLB62 VDD VSS sram_nand2
X175_wldrv RWLB62 WL62 VDD VSS sram_wldrv
X176_nand2 PD0_7 PD1_7 RWLB63 VDD VSS sram_nand2
X177_wldrv RWLB63 WL63 VDD VSS sram_wldrv
XC0_0 BL0 BLB0 WL0 VDD VSS bitcell_6t
XC0_1 BL1 BLB1 WL0 VDD VSS bitcell_6t
XC0_2 BL2 BLB2 WL0 VDD VSS bitcell_6t
XC0_3 BL3 BLB3 WL0 VDD VSS bitcell_6t
XC0_4 BL4 BLB4 WL0 VDD VSS bitcell_6t
XC0_5 BL5 BLB5 WL0 VDD VSS bitcell_6t
XC0_6 BL6 BLB6 WL0 VDD VSS bitcell_6t
XC0_7 BL7 BLB7 WL0 VDD VSS bitcell_6t
XC0_8 BL8 BLB8 WL0 VDD VSS bitcell_6t
XC0_9 BL9 BLB9 WL0 VDD VSS bitcell_6t
XC0_10 BL10 BLB10 WL0 VDD VSS bitcell_6t
XC0_11 BL11 BLB11 WL0 VDD VSS bitcell_6t
XC0_12 BL12 BLB12 WL0 VDD VSS bitcell_6t
XC0_13 BL13 BLB13 WL0 VDD VSS bitcell_6t
XC0_14 BL14 BLB14 WL0 VDD VSS bitcell_6t
XC0_15 BL15 BLB15 WL0 VDD VSS bitcell_6t
XC0_16 BL16 BLB16 WL0 VDD VSS bitcell_6t
XC0_17 BL17 BLB17 WL0 VDD VSS bitcell_6t
XC0_18 BL18 BLB18 WL0 VDD VSS bitcell_6t
XC0_19 BL19 BLB19 WL0 VDD VSS bitcell_6t
XC0_20 BL20 BLB20 WL0 VDD VSS bitcell_6t
XC0_21 BL21 BLB21 WL0 VDD VSS bitcell_6t
XC0_22 BL22 BLB22 WL0 VDD VSS bitcell_6t
XC0_23 BL23 BLB23 WL0 VDD VSS bitcell_6t
XC0_24 BL24 BLB24 WL0 VDD VSS bitcell_6t
XC0_25 BL25 BLB25 WL0 VDD VSS bitcell_6t
XC0_26 BL26 BLB26 WL0 VDD VSS bitcell_6t
XC0_27 BL27 BLB27 WL0 VDD VSS bitcell_6t
XC0_28 BL28 BLB28 WL0 VDD VSS bitcell_6t
XC0_29 BL29 BLB29 WL0 VDD VSS bitcell_6t
XC0_30 BL30 BLB30 WL0 VDD VSS bitcell_6t
XC0_31 BL31 BLB31 WL0 VDD VSS bitcell_6t
XC0_32 BL32 BLB32 WL0 VDD VSS bitcell_6t
XC0_33 BL33 BLB33 WL0 VDD VSS bitcell_6t
XC0_34 BL34 BLB34 WL0 VDD VSS bitcell_6t
XC0_35 BL35 BLB35 WL0 VDD VSS bitcell_6t
XC0_36 BL36 BLB36 WL0 VDD VSS bitcell_6t
XC0_37 BL37 BLB37 WL0 VDD VSS bitcell_6t
XC0_38 BL38 BLB38 WL0 VDD VSS bitcell_6t
XC0_39 BL39 BLB39 WL0 VDD VSS bitcell_6t
XC0_40 BL40 BLB40 WL0 VDD VSS bitcell_6t
XC0_41 BL41 BLB41 WL0 VDD VSS bitcell_6t
XC0_42 BL42 BLB42 WL0 VDD VSS bitcell_6t
XC0_43 BL43 BLB43 WL0 VDD VSS bitcell_6t
XC0_44 BL44 BLB44 WL0 VDD VSS bitcell_6t
XC0_45 BL45 BLB45 WL0 VDD VSS bitcell_6t
XC0_46 BL46 BLB46 WL0 VDD VSS bitcell_6t
XC0_47 BL47 BLB47 WL0 VDD VSS bitcell_6t
XC0_48 BL48 BLB48 WL0 VDD VSS bitcell_6t
XC0_49 BL49 BLB49 WL0 VDD VSS bitcell_6t
XC0_50 BL50 BLB50 WL0 VDD VSS bitcell_6t
XC0_51 BL51 BLB51 WL0 VDD VSS bitcell_6t
XC0_52 BL52 BLB52 WL0 VDD VSS bitcell_6t
XC0_53 BL53 BLB53 WL0 VDD VSS bitcell_6t
XC0_54 BL54 BLB54 WL0 VDD VSS bitcell_6t
XC0_55 BL55 BLB55 WL0 VDD VSS bitcell_6t
XC0_56 BL56 BLB56 WL0 VDD VSS bitcell_6t
XC0_57 BL57 BLB57 WL0 VDD VSS bitcell_6t
XC0_58 BL58 BLB58 WL0 VDD VSS bitcell_6t
XC0_59 BL59 BLB59 WL0 VDD VSS bitcell_6t
XC0_60 BL60 BLB60 WL0 VDD VSS bitcell_6t
XC0_61 BL61 BLB61 WL0 VDD VSS bitcell_6t
XC0_62 BL62 BLB62 WL0 VDD VSS bitcell_6t
XC0_63 BL63 BLB63 WL0 VDD VSS bitcell_6t
XC0_64 BL64 BLB64 WL0 VDD VSS bitcell_6t
XC0_65 BL65 BLB65 WL0 VDD VSS bitcell_6t
XC0_66 BL66 BLB66 WL0 VDD VSS bitcell_6t
XC0_67 BL67 BLB67 WL0 VDD VSS bitcell_6t
XC0_68 BL68 BLB68 WL0 VDD VSS bitcell_6t
XC0_69 BL69 BLB69 WL0 VDD VSS bitcell_6t
XC0_70 BL70 BLB70 WL0 VDD VSS bitcell_6t
XC0_71 BL71 BLB71 WL0 VDD VSS bitcell_6t
XC0_72 BL72 BLB72 WL0 VDD VSS bitcell_6t
XC0_73 BL73 BLB73 WL0 VDD VSS bitcell_6t
XC0_74 BL74 BLB74 WL0 VDD VSS bitcell_6t
XC0_75 BL75 BLB75 WL0 VDD VSS bitcell_6t
XC0_76 BL76 BLB76 WL0 VDD VSS bitcell_6t
XC0_77 BL77 BLB77 WL0 VDD VSS bitcell_6t
XC0_78 BL78 BLB78 WL0 VDD VSS bitcell_6t
XC0_79 BL79 BLB79 WL0 VDD VSS bitcell_6t
XC0_80 BL80 BLB80 WL0 VDD VSS bitcell_6t
XC0_81 BL81 BLB81 WL0 VDD VSS bitcell_6t
XC0_82 BL82 BLB82 WL0 VDD VSS bitcell_6t
XC0_83 BL83 BLB83 WL0 VDD VSS bitcell_6t
XC0_84 BL84 BLB84 WL0 VDD VSS bitcell_6t
XC0_85 BL85 BLB85 WL0 VDD VSS bitcell_6t
XC0_86 BL86 BLB86 WL0 VDD VSS bitcell_6t
XC0_87 BL87 BLB87 WL0 VDD VSS bitcell_6t
XC0_88 BL88 BLB88 WL0 VDD VSS bitcell_6t
XC0_89 BL89 BLB89 WL0 VDD VSS bitcell_6t
XC0_90 BL90 BLB90 WL0 VDD VSS bitcell_6t
XC0_91 BL91 BLB91 WL0 VDD VSS bitcell_6t
XC0_92 BL92 BLB92 WL0 VDD VSS bitcell_6t
XC0_93 BL93 BLB93 WL0 VDD VSS bitcell_6t
XC0_94 BL94 BLB94 WL0 VDD VSS bitcell_6t
XC0_95 BL95 BLB95 WL0 VDD VSS bitcell_6t
XC0_96 BL96 BLB96 WL0 VDD VSS bitcell_6t
XC0_97 BL97 BLB97 WL0 VDD VSS bitcell_6t
XC0_98 BL98 BLB98 WL0 VDD VSS bitcell_6t
XC0_99 BL99 BLB99 WL0 VDD VSS bitcell_6t
XC0_100 BL100 BLB100 WL0 VDD VSS bitcell_6t
XC0_101 BL101 BLB101 WL0 VDD VSS bitcell_6t
XC0_102 BL102 BLB102 WL0 VDD VSS bitcell_6t
XC0_103 BL103 BLB103 WL0 VDD VSS bitcell_6t
XC0_104 BL104 BLB104 WL0 VDD VSS bitcell_6t
XC0_105 BL105 BLB105 WL0 VDD VSS bitcell_6t
XC0_106 BL106 BLB106 WL0 VDD VSS bitcell_6t
XC0_107 BL107 BLB107 WL0 VDD VSS bitcell_6t
XC0_108 BL108 BLB108 WL0 VDD VSS bitcell_6t
XC0_109 BL109 BLB109 WL0 VDD VSS bitcell_6t
XC0_110 BL110 BLB110 WL0 VDD VSS bitcell_6t
XC0_111 BL111 BLB111 WL0 VDD VSS bitcell_6t
XC0_112 BL112 BLB112 WL0 VDD VSS bitcell_6t
XC0_113 BL113 BLB113 WL0 VDD VSS bitcell_6t
XC0_114 BL114 BLB114 WL0 VDD VSS bitcell_6t
XC0_115 BL115 BLB115 WL0 VDD VSS bitcell_6t
XC0_116 BL116 BLB116 WL0 VDD VSS bitcell_6t
XC0_117 BL117 BLB117 WL0 VDD VSS bitcell_6t
XC0_118 BL118 BLB118 WL0 VDD VSS bitcell_6t
XC0_119 BL119 BLB119 WL0 VDD VSS bitcell_6t
XC0_120 BL120 BLB120 WL0 VDD VSS bitcell_6t
XC0_121 BL121 BLB121 WL0 VDD VSS bitcell_6t
XC0_122 BL122 BLB122 WL0 VDD VSS bitcell_6t
XC0_123 BL123 BLB123 WL0 VDD VSS bitcell_6t
XC0_124 BL124 BLB124 WL0 VDD VSS bitcell_6t
XC0_125 BL125 BLB125 WL0 VDD VSS bitcell_6t
XC0_126 BL126 BLB126 WL0 VDD VSS bitcell_6t
XC0_127 BL127 BLB127 WL0 VDD VSS bitcell_6t
XC1_0 BL0 BLB0 WL1 VDD VSS bitcell_6t
XC1_1 BL1 BLB1 WL1 VDD VSS bitcell_6t
XC1_2 BL2 BLB2 WL1 VDD VSS bitcell_6t
XC1_3 BL3 BLB3 WL1 VDD VSS bitcell_6t
XC1_4 BL4 BLB4 WL1 VDD VSS bitcell_6t
XC1_5 BL5 BLB5 WL1 VDD VSS bitcell_6t
XC1_6 BL6 BLB6 WL1 VDD VSS bitcell_6t
XC1_7 BL7 BLB7 WL1 VDD VSS bitcell_6t
XC1_8 BL8 BLB8 WL1 VDD VSS bitcell_6t
XC1_9 BL9 BLB9 WL1 VDD VSS bitcell_6t
XC1_10 BL10 BLB10 WL1 VDD VSS bitcell_6t
XC1_11 BL11 BLB11 WL1 VDD VSS bitcell_6t
XC1_12 BL12 BLB12 WL1 VDD VSS bitcell_6t
XC1_13 BL13 BLB13 WL1 VDD VSS bitcell_6t
XC1_14 BL14 BLB14 WL1 VDD VSS bitcell_6t
XC1_15 BL15 BLB15 WL1 VDD VSS bitcell_6t
XC1_16 BL16 BLB16 WL1 VDD VSS bitcell_6t
XC1_17 BL17 BLB17 WL1 VDD VSS bitcell_6t
XC1_18 BL18 BLB18 WL1 VDD VSS bitcell_6t
XC1_19 BL19 BLB19 WL1 VDD VSS bitcell_6t
XC1_20 BL20 BLB20 WL1 VDD VSS bitcell_6t
XC1_21 BL21 BLB21 WL1 VDD VSS bitcell_6t
XC1_22 BL22 BLB22 WL1 VDD VSS bitcell_6t
XC1_23 BL23 BLB23 WL1 VDD VSS bitcell_6t
XC1_24 BL24 BLB24 WL1 VDD VSS bitcell_6t
XC1_25 BL25 BLB25 WL1 VDD VSS bitcell_6t
XC1_26 BL26 BLB26 WL1 VDD VSS bitcell_6t
XC1_27 BL27 BLB27 WL1 VDD VSS bitcell_6t
XC1_28 BL28 BLB28 WL1 VDD VSS bitcell_6t
XC1_29 BL29 BLB29 WL1 VDD VSS bitcell_6t
XC1_30 BL30 BLB30 WL1 VDD VSS bitcell_6t
XC1_31 BL31 BLB31 WL1 VDD VSS bitcell_6t
XC1_32 BL32 BLB32 WL1 VDD VSS bitcell_6t
XC1_33 BL33 BLB33 WL1 VDD VSS bitcell_6t
XC1_34 BL34 BLB34 WL1 VDD VSS bitcell_6t
XC1_35 BL35 BLB35 WL1 VDD VSS bitcell_6t
XC1_36 BL36 BLB36 WL1 VDD VSS bitcell_6t
XC1_37 BL37 BLB37 WL1 VDD VSS bitcell_6t
XC1_38 BL38 BLB38 WL1 VDD VSS bitcell_6t
XC1_39 BL39 BLB39 WL1 VDD VSS bitcell_6t
XC1_40 BL40 BLB40 WL1 VDD VSS bitcell_6t
XC1_41 BL41 BLB41 WL1 VDD VSS bitcell_6t
XC1_42 BL42 BLB42 WL1 VDD VSS bitcell_6t
XC1_43 BL43 BLB43 WL1 VDD VSS bitcell_6t
XC1_44 BL44 BLB44 WL1 VDD VSS bitcell_6t
XC1_45 BL45 BLB45 WL1 VDD VSS bitcell_6t
XC1_46 BL46 BLB46 WL1 VDD VSS bitcell_6t
XC1_47 BL47 BLB47 WL1 VDD VSS bitcell_6t
XC1_48 BL48 BLB48 WL1 VDD VSS bitcell_6t
XC1_49 BL49 BLB49 WL1 VDD VSS bitcell_6t
XC1_50 BL50 BLB50 WL1 VDD VSS bitcell_6t
XC1_51 BL51 BLB51 WL1 VDD VSS bitcell_6t
XC1_52 BL52 BLB52 WL1 VDD VSS bitcell_6t
XC1_53 BL53 BLB53 WL1 VDD VSS bitcell_6t
XC1_54 BL54 BLB54 WL1 VDD VSS bitcell_6t
XC1_55 BL55 BLB55 WL1 VDD VSS bitcell_6t
XC1_56 BL56 BLB56 WL1 VDD VSS bitcell_6t
XC1_57 BL57 BLB57 WL1 VDD VSS bitcell_6t
XC1_58 BL58 BLB58 WL1 VDD VSS bitcell_6t
XC1_59 BL59 BLB59 WL1 VDD VSS bitcell_6t
XC1_60 BL60 BLB60 WL1 VDD VSS bitcell_6t
XC1_61 BL61 BLB61 WL1 VDD VSS bitcell_6t
XC1_62 BL62 BLB62 WL1 VDD VSS bitcell_6t
XC1_63 BL63 BLB63 WL1 VDD VSS bitcell_6t
XC1_64 BL64 BLB64 WL1 VDD VSS bitcell_6t
XC1_65 BL65 BLB65 WL1 VDD VSS bitcell_6t
XC1_66 BL66 BLB66 WL1 VDD VSS bitcell_6t
XC1_67 BL67 BLB67 WL1 VDD VSS bitcell_6t
XC1_68 BL68 BLB68 WL1 VDD VSS bitcell_6t
XC1_69 BL69 BLB69 WL1 VDD VSS bitcell_6t
XC1_70 BL70 BLB70 WL1 VDD VSS bitcell_6t
XC1_71 BL71 BLB71 WL1 VDD VSS bitcell_6t
XC1_72 BL72 BLB72 WL1 VDD VSS bitcell_6t
XC1_73 BL73 BLB73 WL1 VDD VSS bitcell_6t
XC1_74 BL74 BLB74 WL1 VDD VSS bitcell_6t
XC1_75 BL75 BLB75 WL1 VDD VSS bitcell_6t
XC1_76 BL76 BLB76 WL1 VDD VSS bitcell_6t
XC1_77 BL77 BLB77 WL1 VDD VSS bitcell_6t
XC1_78 BL78 BLB78 WL1 VDD VSS bitcell_6t
XC1_79 BL79 BLB79 WL1 VDD VSS bitcell_6t
XC1_80 BL80 BLB80 WL1 VDD VSS bitcell_6t
XC1_81 BL81 BLB81 WL1 VDD VSS bitcell_6t
XC1_82 BL82 BLB82 WL1 VDD VSS bitcell_6t
XC1_83 BL83 BLB83 WL1 VDD VSS bitcell_6t
XC1_84 BL84 BLB84 WL1 VDD VSS bitcell_6t
XC1_85 BL85 BLB85 WL1 VDD VSS bitcell_6t
XC1_86 BL86 BLB86 WL1 VDD VSS bitcell_6t
XC1_87 BL87 BLB87 WL1 VDD VSS bitcell_6t
XC1_88 BL88 BLB88 WL1 VDD VSS bitcell_6t
XC1_89 BL89 BLB89 WL1 VDD VSS bitcell_6t
XC1_90 BL90 BLB90 WL1 VDD VSS bitcell_6t
XC1_91 BL91 BLB91 WL1 VDD VSS bitcell_6t
XC1_92 BL92 BLB92 WL1 VDD VSS bitcell_6t
XC1_93 BL93 BLB93 WL1 VDD VSS bitcell_6t
XC1_94 BL94 BLB94 WL1 VDD VSS bitcell_6t
XC1_95 BL95 BLB95 WL1 VDD VSS bitcell_6t
XC1_96 BL96 BLB96 WL1 VDD VSS bitcell_6t
XC1_97 BL97 BLB97 WL1 VDD VSS bitcell_6t
XC1_98 BL98 BLB98 WL1 VDD VSS bitcell_6t
XC1_99 BL99 BLB99 WL1 VDD VSS bitcell_6t
XC1_100 BL100 BLB100 WL1 VDD VSS bitcell_6t
XC1_101 BL101 BLB101 WL1 VDD VSS bitcell_6t
XC1_102 BL102 BLB102 WL1 VDD VSS bitcell_6t
XC1_103 BL103 BLB103 WL1 VDD VSS bitcell_6t
XC1_104 BL104 BLB104 WL1 VDD VSS bitcell_6t
XC1_105 BL105 BLB105 WL1 VDD VSS bitcell_6t
XC1_106 BL106 BLB106 WL1 VDD VSS bitcell_6t
XC1_107 BL107 BLB107 WL1 VDD VSS bitcell_6t
XC1_108 BL108 BLB108 WL1 VDD VSS bitcell_6t
XC1_109 BL109 BLB109 WL1 VDD VSS bitcell_6t
XC1_110 BL110 BLB110 WL1 VDD VSS bitcell_6t
XC1_111 BL111 BLB111 WL1 VDD VSS bitcell_6t
XC1_112 BL112 BLB112 WL1 VDD VSS bitcell_6t
XC1_113 BL113 BLB113 WL1 VDD VSS bitcell_6t
XC1_114 BL114 BLB114 WL1 VDD VSS bitcell_6t
XC1_115 BL115 BLB115 WL1 VDD VSS bitcell_6t
XC1_116 BL116 BLB116 WL1 VDD VSS bitcell_6t
XC1_117 BL117 BLB117 WL1 VDD VSS bitcell_6t
XC1_118 BL118 BLB118 WL1 VDD VSS bitcell_6t
XC1_119 BL119 BLB119 WL1 VDD VSS bitcell_6t
XC1_120 BL120 BLB120 WL1 VDD VSS bitcell_6t
XC1_121 BL121 BLB121 WL1 VDD VSS bitcell_6t
XC1_122 BL122 BLB122 WL1 VDD VSS bitcell_6t
XC1_123 BL123 BLB123 WL1 VDD VSS bitcell_6t
XC1_124 BL124 BLB124 WL1 VDD VSS bitcell_6t
XC1_125 BL125 BLB125 WL1 VDD VSS bitcell_6t
XC1_126 BL126 BLB126 WL1 VDD VSS bitcell_6t
XC1_127 BL127 BLB127 WL1 VDD VSS bitcell_6t
XC2_0 BL0 BLB0 WL2 VDD VSS bitcell_6t
XC2_1 BL1 BLB1 WL2 VDD VSS bitcell_6t
XC2_2 BL2 BLB2 WL2 VDD VSS bitcell_6t
XC2_3 BL3 BLB3 WL2 VDD VSS bitcell_6t
XC2_4 BL4 BLB4 WL2 VDD VSS bitcell_6t
XC2_5 BL5 BLB5 WL2 VDD VSS bitcell_6t
XC2_6 BL6 BLB6 WL2 VDD VSS bitcell_6t
XC2_7 BL7 BLB7 WL2 VDD VSS bitcell_6t
XC2_8 BL8 BLB8 WL2 VDD VSS bitcell_6t
XC2_9 BL9 BLB9 WL2 VDD VSS bitcell_6t
XC2_10 BL10 BLB10 WL2 VDD VSS bitcell_6t
XC2_11 BL11 BLB11 WL2 VDD VSS bitcell_6t
XC2_12 BL12 BLB12 WL2 VDD VSS bitcell_6t
XC2_13 BL13 BLB13 WL2 VDD VSS bitcell_6t
XC2_14 BL14 BLB14 WL2 VDD VSS bitcell_6t
XC2_15 BL15 BLB15 WL2 VDD VSS bitcell_6t
XC2_16 BL16 BLB16 WL2 VDD VSS bitcell_6t
XC2_17 BL17 BLB17 WL2 VDD VSS bitcell_6t
XC2_18 BL18 BLB18 WL2 VDD VSS bitcell_6t
XC2_19 BL19 BLB19 WL2 VDD VSS bitcell_6t
XC2_20 BL20 BLB20 WL2 VDD VSS bitcell_6t
XC2_21 BL21 BLB21 WL2 VDD VSS bitcell_6t
XC2_22 BL22 BLB22 WL2 VDD VSS bitcell_6t
XC2_23 BL23 BLB23 WL2 VDD VSS bitcell_6t
XC2_24 BL24 BLB24 WL2 VDD VSS bitcell_6t
XC2_25 BL25 BLB25 WL2 VDD VSS bitcell_6t
XC2_26 BL26 BLB26 WL2 VDD VSS bitcell_6t
XC2_27 BL27 BLB27 WL2 VDD VSS bitcell_6t
XC2_28 BL28 BLB28 WL2 VDD VSS bitcell_6t
XC2_29 BL29 BLB29 WL2 VDD VSS bitcell_6t
XC2_30 BL30 BLB30 WL2 VDD VSS bitcell_6t
XC2_31 BL31 BLB31 WL2 VDD VSS bitcell_6t
XC2_32 BL32 BLB32 WL2 VDD VSS bitcell_6t
XC2_33 BL33 BLB33 WL2 VDD VSS bitcell_6t
XC2_34 BL34 BLB34 WL2 VDD VSS bitcell_6t
XC2_35 BL35 BLB35 WL2 VDD VSS bitcell_6t
XC2_36 BL36 BLB36 WL2 VDD VSS bitcell_6t
XC2_37 BL37 BLB37 WL2 VDD VSS bitcell_6t
XC2_38 BL38 BLB38 WL2 VDD VSS bitcell_6t
XC2_39 BL39 BLB39 WL2 VDD VSS bitcell_6t
XC2_40 BL40 BLB40 WL2 VDD VSS bitcell_6t
XC2_41 BL41 BLB41 WL2 VDD VSS bitcell_6t
XC2_42 BL42 BLB42 WL2 VDD VSS bitcell_6t
XC2_43 BL43 BLB43 WL2 VDD VSS bitcell_6t
XC2_44 BL44 BLB44 WL2 VDD VSS bitcell_6t
XC2_45 BL45 BLB45 WL2 VDD VSS bitcell_6t
XC2_46 BL46 BLB46 WL2 VDD VSS bitcell_6t
XC2_47 BL47 BLB47 WL2 VDD VSS bitcell_6t
XC2_48 BL48 BLB48 WL2 VDD VSS bitcell_6t
XC2_49 BL49 BLB49 WL2 VDD VSS bitcell_6t
XC2_50 BL50 BLB50 WL2 VDD VSS bitcell_6t
XC2_51 BL51 BLB51 WL2 VDD VSS bitcell_6t
XC2_52 BL52 BLB52 WL2 VDD VSS bitcell_6t
XC2_53 BL53 BLB53 WL2 VDD VSS bitcell_6t
XC2_54 BL54 BLB54 WL2 VDD VSS bitcell_6t
XC2_55 BL55 BLB55 WL2 VDD VSS bitcell_6t
XC2_56 BL56 BLB56 WL2 VDD VSS bitcell_6t
XC2_57 BL57 BLB57 WL2 VDD VSS bitcell_6t
XC2_58 BL58 BLB58 WL2 VDD VSS bitcell_6t
XC2_59 BL59 BLB59 WL2 VDD VSS bitcell_6t
XC2_60 BL60 BLB60 WL2 VDD VSS bitcell_6t
XC2_61 BL61 BLB61 WL2 VDD VSS bitcell_6t
XC2_62 BL62 BLB62 WL2 VDD VSS bitcell_6t
XC2_63 BL63 BLB63 WL2 VDD VSS bitcell_6t
XC2_64 BL64 BLB64 WL2 VDD VSS bitcell_6t
XC2_65 BL65 BLB65 WL2 VDD VSS bitcell_6t
XC2_66 BL66 BLB66 WL2 VDD VSS bitcell_6t
XC2_67 BL67 BLB67 WL2 VDD VSS bitcell_6t
XC2_68 BL68 BLB68 WL2 VDD VSS bitcell_6t
XC2_69 BL69 BLB69 WL2 VDD VSS bitcell_6t
XC2_70 BL70 BLB70 WL2 VDD VSS bitcell_6t
XC2_71 BL71 BLB71 WL2 VDD VSS bitcell_6t
XC2_72 BL72 BLB72 WL2 VDD VSS bitcell_6t
XC2_73 BL73 BLB73 WL2 VDD VSS bitcell_6t
XC2_74 BL74 BLB74 WL2 VDD VSS bitcell_6t
XC2_75 BL75 BLB75 WL2 VDD VSS bitcell_6t
XC2_76 BL76 BLB76 WL2 VDD VSS bitcell_6t
XC2_77 BL77 BLB77 WL2 VDD VSS bitcell_6t
XC2_78 BL78 BLB78 WL2 VDD VSS bitcell_6t
XC2_79 BL79 BLB79 WL2 VDD VSS bitcell_6t
XC2_80 BL80 BLB80 WL2 VDD VSS bitcell_6t
XC2_81 BL81 BLB81 WL2 VDD VSS bitcell_6t
XC2_82 BL82 BLB82 WL2 VDD VSS bitcell_6t
XC2_83 BL83 BLB83 WL2 VDD VSS bitcell_6t
XC2_84 BL84 BLB84 WL2 VDD VSS bitcell_6t
XC2_85 BL85 BLB85 WL2 VDD VSS bitcell_6t
XC2_86 BL86 BLB86 WL2 VDD VSS bitcell_6t
XC2_87 BL87 BLB87 WL2 VDD VSS bitcell_6t
XC2_88 BL88 BLB88 WL2 VDD VSS bitcell_6t
XC2_89 BL89 BLB89 WL2 VDD VSS bitcell_6t
XC2_90 BL90 BLB90 WL2 VDD VSS bitcell_6t
XC2_91 BL91 BLB91 WL2 VDD VSS bitcell_6t
XC2_92 BL92 BLB92 WL2 VDD VSS bitcell_6t
XC2_93 BL93 BLB93 WL2 VDD VSS bitcell_6t
XC2_94 BL94 BLB94 WL2 VDD VSS bitcell_6t
XC2_95 BL95 BLB95 WL2 VDD VSS bitcell_6t
XC2_96 BL96 BLB96 WL2 VDD VSS bitcell_6t
XC2_97 BL97 BLB97 WL2 VDD VSS bitcell_6t
XC2_98 BL98 BLB98 WL2 VDD VSS bitcell_6t
XC2_99 BL99 BLB99 WL2 VDD VSS bitcell_6t
XC2_100 BL100 BLB100 WL2 VDD VSS bitcell_6t
XC2_101 BL101 BLB101 WL2 VDD VSS bitcell_6t
XC2_102 BL102 BLB102 WL2 VDD VSS bitcell_6t
XC2_103 BL103 BLB103 WL2 VDD VSS bitcell_6t
XC2_104 BL104 BLB104 WL2 VDD VSS bitcell_6t
XC2_105 BL105 BLB105 WL2 VDD VSS bitcell_6t
XC2_106 BL106 BLB106 WL2 VDD VSS bitcell_6t
XC2_107 BL107 BLB107 WL2 VDD VSS bitcell_6t
XC2_108 BL108 BLB108 WL2 VDD VSS bitcell_6t
XC2_109 BL109 BLB109 WL2 VDD VSS bitcell_6t
XC2_110 BL110 BLB110 WL2 VDD VSS bitcell_6t
XC2_111 BL111 BLB111 WL2 VDD VSS bitcell_6t
XC2_112 BL112 BLB112 WL2 VDD VSS bitcell_6t
XC2_113 BL113 BLB113 WL2 VDD VSS bitcell_6t
XC2_114 BL114 BLB114 WL2 VDD VSS bitcell_6t
XC2_115 BL115 BLB115 WL2 VDD VSS bitcell_6t
XC2_116 BL116 BLB116 WL2 VDD VSS bitcell_6t
XC2_117 BL117 BLB117 WL2 VDD VSS bitcell_6t
XC2_118 BL118 BLB118 WL2 VDD VSS bitcell_6t
XC2_119 BL119 BLB119 WL2 VDD VSS bitcell_6t
XC2_120 BL120 BLB120 WL2 VDD VSS bitcell_6t
XC2_121 BL121 BLB121 WL2 VDD VSS bitcell_6t
XC2_122 BL122 BLB122 WL2 VDD VSS bitcell_6t
XC2_123 BL123 BLB123 WL2 VDD VSS bitcell_6t
XC2_124 BL124 BLB124 WL2 VDD VSS bitcell_6t
XC2_125 BL125 BLB125 WL2 VDD VSS bitcell_6t
XC2_126 BL126 BLB126 WL2 VDD VSS bitcell_6t
XC2_127 BL127 BLB127 WL2 VDD VSS bitcell_6t
XC3_0 BL0 BLB0 WL3 VDD VSS bitcell_6t
XC3_1 BL1 BLB1 WL3 VDD VSS bitcell_6t
XC3_2 BL2 BLB2 WL3 VDD VSS bitcell_6t
XC3_3 BL3 BLB3 WL3 VDD VSS bitcell_6t
XC3_4 BL4 BLB4 WL3 VDD VSS bitcell_6t
XC3_5 BL5 BLB5 WL3 VDD VSS bitcell_6t
XC3_6 BL6 BLB6 WL3 VDD VSS bitcell_6t
XC3_7 BL7 BLB7 WL3 VDD VSS bitcell_6t
XC3_8 BL8 BLB8 WL3 VDD VSS bitcell_6t
XC3_9 BL9 BLB9 WL3 VDD VSS bitcell_6t
XC3_10 BL10 BLB10 WL3 VDD VSS bitcell_6t
XC3_11 BL11 BLB11 WL3 VDD VSS bitcell_6t
XC3_12 BL12 BLB12 WL3 VDD VSS bitcell_6t
XC3_13 BL13 BLB13 WL3 VDD VSS bitcell_6t
XC3_14 BL14 BLB14 WL3 VDD VSS bitcell_6t
XC3_15 BL15 BLB15 WL3 VDD VSS bitcell_6t
XC3_16 BL16 BLB16 WL3 VDD VSS bitcell_6t
XC3_17 BL17 BLB17 WL3 VDD VSS bitcell_6t
XC3_18 BL18 BLB18 WL3 VDD VSS bitcell_6t
XC3_19 BL19 BLB19 WL3 VDD VSS bitcell_6t
XC3_20 BL20 BLB20 WL3 VDD VSS bitcell_6t
XC3_21 BL21 BLB21 WL3 VDD VSS bitcell_6t
XC3_22 BL22 BLB22 WL3 VDD VSS bitcell_6t
XC3_23 BL23 BLB23 WL3 VDD VSS bitcell_6t
XC3_24 BL24 BLB24 WL3 VDD VSS bitcell_6t
XC3_25 BL25 BLB25 WL3 VDD VSS bitcell_6t
XC3_26 BL26 BLB26 WL3 VDD VSS bitcell_6t
XC3_27 BL27 BLB27 WL3 VDD VSS bitcell_6t
XC3_28 BL28 BLB28 WL3 VDD VSS bitcell_6t
XC3_29 BL29 BLB29 WL3 VDD VSS bitcell_6t
XC3_30 BL30 BLB30 WL3 VDD VSS bitcell_6t
XC3_31 BL31 BLB31 WL3 VDD VSS bitcell_6t
XC3_32 BL32 BLB32 WL3 VDD VSS bitcell_6t
XC3_33 BL33 BLB33 WL3 VDD VSS bitcell_6t
XC3_34 BL34 BLB34 WL3 VDD VSS bitcell_6t
XC3_35 BL35 BLB35 WL3 VDD VSS bitcell_6t
XC3_36 BL36 BLB36 WL3 VDD VSS bitcell_6t
XC3_37 BL37 BLB37 WL3 VDD VSS bitcell_6t
XC3_38 BL38 BLB38 WL3 VDD VSS bitcell_6t
XC3_39 BL39 BLB39 WL3 VDD VSS bitcell_6t
XC3_40 BL40 BLB40 WL3 VDD VSS bitcell_6t
XC3_41 BL41 BLB41 WL3 VDD VSS bitcell_6t
XC3_42 BL42 BLB42 WL3 VDD VSS bitcell_6t
XC3_43 BL43 BLB43 WL3 VDD VSS bitcell_6t
XC3_44 BL44 BLB44 WL3 VDD VSS bitcell_6t
XC3_45 BL45 BLB45 WL3 VDD VSS bitcell_6t
XC3_46 BL46 BLB46 WL3 VDD VSS bitcell_6t
XC3_47 BL47 BLB47 WL3 VDD VSS bitcell_6t
XC3_48 BL48 BLB48 WL3 VDD VSS bitcell_6t
XC3_49 BL49 BLB49 WL3 VDD VSS bitcell_6t
XC3_50 BL50 BLB50 WL3 VDD VSS bitcell_6t
XC3_51 BL51 BLB51 WL3 VDD VSS bitcell_6t
XC3_52 BL52 BLB52 WL3 VDD VSS bitcell_6t
XC3_53 BL53 BLB53 WL3 VDD VSS bitcell_6t
XC3_54 BL54 BLB54 WL3 VDD VSS bitcell_6t
XC3_55 BL55 BLB55 WL3 VDD VSS bitcell_6t
XC3_56 BL56 BLB56 WL3 VDD VSS bitcell_6t
XC3_57 BL57 BLB57 WL3 VDD VSS bitcell_6t
XC3_58 BL58 BLB58 WL3 VDD VSS bitcell_6t
XC3_59 BL59 BLB59 WL3 VDD VSS bitcell_6t
XC3_60 BL60 BLB60 WL3 VDD VSS bitcell_6t
XC3_61 BL61 BLB61 WL3 VDD VSS bitcell_6t
XC3_62 BL62 BLB62 WL3 VDD VSS bitcell_6t
XC3_63 BL63 BLB63 WL3 VDD VSS bitcell_6t
XC3_64 BL64 BLB64 WL3 VDD VSS bitcell_6t
XC3_65 BL65 BLB65 WL3 VDD VSS bitcell_6t
XC3_66 BL66 BLB66 WL3 VDD VSS bitcell_6t
XC3_67 BL67 BLB67 WL3 VDD VSS bitcell_6t
XC3_68 BL68 BLB68 WL3 VDD VSS bitcell_6t
XC3_69 BL69 BLB69 WL3 VDD VSS bitcell_6t
XC3_70 BL70 BLB70 WL3 VDD VSS bitcell_6t
XC3_71 BL71 BLB71 WL3 VDD VSS bitcell_6t
XC3_72 BL72 BLB72 WL3 VDD VSS bitcell_6t
XC3_73 BL73 BLB73 WL3 VDD VSS bitcell_6t
XC3_74 BL74 BLB74 WL3 VDD VSS bitcell_6t
XC3_75 BL75 BLB75 WL3 VDD VSS bitcell_6t
XC3_76 BL76 BLB76 WL3 VDD VSS bitcell_6t
XC3_77 BL77 BLB77 WL3 VDD VSS bitcell_6t
XC3_78 BL78 BLB78 WL3 VDD VSS bitcell_6t
XC3_79 BL79 BLB79 WL3 VDD VSS bitcell_6t
XC3_80 BL80 BLB80 WL3 VDD VSS bitcell_6t
XC3_81 BL81 BLB81 WL3 VDD VSS bitcell_6t
XC3_82 BL82 BLB82 WL3 VDD VSS bitcell_6t
XC3_83 BL83 BLB83 WL3 VDD VSS bitcell_6t
XC3_84 BL84 BLB84 WL3 VDD VSS bitcell_6t
XC3_85 BL85 BLB85 WL3 VDD VSS bitcell_6t
XC3_86 BL86 BLB86 WL3 VDD VSS bitcell_6t
XC3_87 BL87 BLB87 WL3 VDD VSS bitcell_6t
XC3_88 BL88 BLB88 WL3 VDD VSS bitcell_6t
XC3_89 BL89 BLB89 WL3 VDD VSS bitcell_6t
XC3_90 BL90 BLB90 WL3 VDD VSS bitcell_6t
XC3_91 BL91 BLB91 WL3 VDD VSS bitcell_6t
XC3_92 BL92 BLB92 WL3 VDD VSS bitcell_6t
XC3_93 BL93 BLB93 WL3 VDD VSS bitcell_6t
XC3_94 BL94 BLB94 WL3 VDD VSS bitcell_6t
XC3_95 BL95 BLB95 WL3 VDD VSS bitcell_6t
XC3_96 BL96 BLB96 WL3 VDD VSS bitcell_6t
XC3_97 BL97 BLB97 WL3 VDD VSS bitcell_6t
XC3_98 BL98 BLB98 WL3 VDD VSS bitcell_6t
XC3_99 BL99 BLB99 WL3 VDD VSS bitcell_6t
XC3_100 BL100 BLB100 WL3 VDD VSS bitcell_6t
XC3_101 BL101 BLB101 WL3 VDD VSS bitcell_6t
XC3_102 BL102 BLB102 WL3 VDD VSS bitcell_6t
XC3_103 BL103 BLB103 WL3 VDD VSS bitcell_6t
XC3_104 BL104 BLB104 WL3 VDD VSS bitcell_6t
XC3_105 BL105 BLB105 WL3 VDD VSS bitcell_6t
XC3_106 BL106 BLB106 WL3 VDD VSS bitcell_6t
XC3_107 BL107 BLB107 WL3 VDD VSS bitcell_6t
XC3_108 BL108 BLB108 WL3 VDD VSS bitcell_6t
XC3_109 BL109 BLB109 WL3 VDD VSS bitcell_6t
XC3_110 BL110 BLB110 WL3 VDD VSS bitcell_6t
XC3_111 BL111 BLB111 WL3 VDD VSS bitcell_6t
XC3_112 BL112 BLB112 WL3 VDD VSS bitcell_6t
XC3_113 BL113 BLB113 WL3 VDD VSS bitcell_6t
XC3_114 BL114 BLB114 WL3 VDD VSS bitcell_6t
XC3_115 BL115 BLB115 WL3 VDD VSS bitcell_6t
XC3_116 BL116 BLB116 WL3 VDD VSS bitcell_6t
XC3_117 BL117 BLB117 WL3 VDD VSS bitcell_6t
XC3_118 BL118 BLB118 WL3 VDD VSS bitcell_6t
XC3_119 BL119 BLB119 WL3 VDD VSS bitcell_6t
XC3_120 BL120 BLB120 WL3 VDD VSS bitcell_6t
XC3_121 BL121 BLB121 WL3 VDD VSS bitcell_6t
XC3_122 BL122 BLB122 WL3 VDD VSS bitcell_6t
XC3_123 BL123 BLB123 WL3 VDD VSS bitcell_6t
XC3_124 BL124 BLB124 WL3 VDD VSS bitcell_6t
XC3_125 BL125 BLB125 WL3 VDD VSS bitcell_6t
XC3_126 BL126 BLB126 WL3 VDD VSS bitcell_6t
XC3_127 BL127 BLB127 WL3 VDD VSS bitcell_6t
XC4_0 BL0 BLB0 WL4 VDD VSS bitcell_6t
XC4_1 BL1 BLB1 WL4 VDD VSS bitcell_6t
XC4_2 BL2 BLB2 WL4 VDD VSS bitcell_6t
XC4_3 BL3 BLB3 WL4 VDD VSS bitcell_6t
XC4_4 BL4 BLB4 WL4 VDD VSS bitcell_6t
XC4_5 BL5 BLB5 WL4 VDD VSS bitcell_6t
XC4_6 BL6 BLB6 WL4 VDD VSS bitcell_6t
XC4_7 BL7 BLB7 WL4 VDD VSS bitcell_6t
XC4_8 BL8 BLB8 WL4 VDD VSS bitcell_6t
XC4_9 BL9 BLB9 WL4 VDD VSS bitcell_6t
XC4_10 BL10 BLB10 WL4 VDD VSS bitcell_6t
XC4_11 BL11 BLB11 WL4 VDD VSS bitcell_6t
XC4_12 BL12 BLB12 WL4 VDD VSS bitcell_6t
XC4_13 BL13 BLB13 WL4 VDD VSS bitcell_6t
XC4_14 BL14 BLB14 WL4 VDD VSS bitcell_6t
XC4_15 BL15 BLB15 WL4 VDD VSS bitcell_6t
XC4_16 BL16 BLB16 WL4 VDD VSS bitcell_6t
XC4_17 BL17 BLB17 WL4 VDD VSS bitcell_6t
XC4_18 BL18 BLB18 WL4 VDD VSS bitcell_6t
XC4_19 BL19 BLB19 WL4 VDD VSS bitcell_6t
XC4_20 BL20 BLB20 WL4 VDD VSS bitcell_6t
XC4_21 BL21 BLB21 WL4 VDD VSS bitcell_6t
XC4_22 BL22 BLB22 WL4 VDD VSS bitcell_6t
XC4_23 BL23 BLB23 WL4 VDD VSS bitcell_6t
XC4_24 BL24 BLB24 WL4 VDD VSS bitcell_6t
XC4_25 BL25 BLB25 WL4 VDD VSS bitcell_6t
XC4_26 BL26 BLB26 WL4 VDD VSS bitcell_6t
XC4_27 BL27 BLB27 WL4 VDD VSS bitcell_6t
XC4_28 BL28 BLB28 WL4 VDD VSS bitcell_6t
XC4_29 BL29 BLB29 WL4 VDD VSS bitcell_6t
XC4_30 BL30 BLB30 WL4 VDD VSS bitcell_6t
XC4_31 BL31 BLB31 WL4 VDD VSS bitcell_6t
XC4_32 BL32 BLB32 WL4 VDD VSS bitcell_6t
XC4_33 BL33 BLB33 WL4 VDD VSS bitcell_6t
XC4_34 BL34 BLB34 WL4 VDD VSS bitcell_6t
XC4_35 BL35 BLB35 WL4 VDD VSS bitcell_6t
XC4_36 BL36 BLB36 WL4 VDD VSS bitcell_6t
XC4_37 BL37 BLB37 WL4 VDD VSS bitcell_6t
XC4_38 BL38 BLB38 WL4 VDD VSS bitcell_6t
XC4_39 BL39 BLB39 WL4 VDD VSS bitcell_6t
XC4_40 BL40 BLB40 WL4 VDD VSS bitcell_6t
XC4_41 BL41 BLB41 WL4 VDD VSS bitcell_6t
XC4_42 BL42 BLB42 WL4 VDD VSS bitcell_6t
XC4_43 BL43 BLB43 WL4 VDD VSS bitcell_6t
XC4_44 BL44 BLB44 WL4 VDD VSS bitcell_6t
XC4_45 BL45 BLB45 WL4 VDD VSS bitcell_6t
XC4_46 BL46 BLB46 WL4 VDD VSS bitcell_6t
XC4_47 BL47 BLB47 WL4 VDD VSS bitcell_6t
XC4_48 BL48 BLB48 WL4 VDD VSS bitcell_6t
XC4_49 BL49 BLB49 WL4 VDD VSS bitcell_6t
XC4_50 BL50 BLB50 WL4 VDD VSS bitcell_6t
XC4_51 BL51 BLB51 WL4 VDD VSS bitcell_6t
XC4_52 BL52 BLB52 WL4 VDD VSS bitcell_6t
XC4_53 BL53 BLB53 WL4 VDD VSS bitcell_6t
XC4_54 BL54 BLB54 WL4 VDD VSS bitcell_6t
XC4_55 BL55 BLB55 WL4 VDD VSS bitcell_6t
XC4_56 BL56 BLB56 WL4 VDD VSS bitcell_6t
XC4_57 BL57 BLB57 WL4 VDD VSS bitcell_6t
XC4_58 BL58 BLB58 WL4 VDD VSS bitcell_6t
XC4_59 BL59 BLB59 WL4 VDD VSS bitcell_6t
XC4_60 BL60 BLB60 WL4 VDD VSS bitcell_6t
XC4_61 BL61 BLB61 WL4 VDD VSS bitcell_6t
XC4_62 BL62 BLB62 WL4 VDD VSS bitcell_6t
XC4_63 BL63 BLB63 WL4 VDD VSS bitcell_6t
XC4_64 BL64 BLB64 WL4 VDD VSS bitcell_6t
XC4_65 BL65 BLB65 WL4 VDD VSS bitcell_6t
XC4_66 BL66 BLB66 WL4 VDD VSS bitcell_6t
XC4_67 BL67 BLB67 WL4 VDD VSS bitcell_6t
XC4_68 BL68 BLB68 WL4 VDD VSS bitcell_6t
XC4_69 BL69 BLB69 WL4 VDD VSS bitcell_6t
XC4_70 BL70 BLB70 WL4 VDD VSS bitcell_6t
XC4_71 BL71 BLB71 WL4 VDD VSS bitcell_6t
XC4_72 BL72 BLB72 WL4 VDD VSS bitcell_6t
XC4_73 BL73 BLB73 WL4 VDD VSS bitcell_6t
XC4_74 BL74 BLB74 WL4 VDD VSS bitcell_6t
XC4_75 BL75 BLB75 WL4 VDD VSS bitcell_6t
XC4_76 BL76 BLB76 WL4 VDD VSS bitcell_6t
XC4_77 BL77 BLB77 WL4 VDD VSS bitcell_6t
XC4_78 BL78 BLB78 WL4 VDD VSS bitcell_6t
XC4_79 BL79 BLB79 WL4 VDD VSS bitcell_6t
XC4_80 BL80 BLB80 WL4 VDD VSS bitcell_6t
XC4_81 BL81 BLB81 WL4 VDD VSS bitcell_6t
XC4_82 BL82 BLB82 WL4 VDD VSS bitcell_6t
XC4_83 BL83 BLB83 WL4 VDD VSS bitcell_6t
XC4_84 BL84 BLB84 WL4 VDD VSS bitcell_6t
XC4_85 BL85 BLB85 WL4 VDD VSS bitcell_6t
XC4_86 BL86 BLB86 WL4 VDD VSS bitcell_6t
XC4_87 BL87 BLB87 WL4 VDD VSS bitcell_6t
XC4_88 BL88 BLB88 WL4 VDD VSS bitcell_6t
XC4_89 BL89 BLB89 WL4 VDD VSS bitcell_6t
XC4_90 BL90 BLB90 WL4 VDD VSS bitcell_6t
XC4_91 BL91 BLB91 WL4 VDD VSS bitcell_6t
XC4_92 BL92 BLB92 WL4 VDD VSS bitcell_6t
XC4_93 BL93 BLB93 WL4 VDD VSS bitcell_6t
XC4_94 BL94 BLB94 WL4 VDD VSS bitcell_6t
XC4_95 BL95 BLB95 WL4 VDD VSS bitcell_6t
XC4_96 BL96 BLB96 WL4 VDD VSS bitcell_6t
XC4_97 BL97 BLB97 WL4 VDD VSS bitcell_6t
XC4_98 BL98 BLB98 WL4 VDD VSS bitcell_6t
XC4_99 BL99 BLB99 WL4 VDD VSS bitcell_6t
XC4_100 BL100 BLB100 WL4 VDD VSS bitcell_6t
XC4_101 BL101 BLB101 WL4 VDD VSS bitcell_6t
XC4_102 BL102 BLB102 WL4 VDD VSS bitcell_6t
XC4_103 BL103 BLB103 WL4 VDD VSS bitcell_6t
XC4_104 BL104 BLB104 WL4 VDD VSS bitcell_6t
XC4_105 BL105 BLB105 WL4 VDD VSS bitcell_6t
XC4_106 BL106 BLB106 WL4 VDD VSS bitcell_6t
XC4_107 BL107 BLB107 WL4 VDD VSS bitcell_6t
XC4_108 BL108 BLB108 WL4 VDD VSS bitcell_6t
XC4_109 BL109 BLB109 WL4 VDD VSS bitcell_6t
XC4_110 BL110 BLB110 WL4 VDD VSS bitcell_6t
XC4_111 BL111 BLB111 WL4 VDD VSS bitcell_6t
XC4_112 BL112 BLB112 WL4 VDD VSS bitcell_6t
XC4_113 BL113 BLB113 WL4 VDD VSS bitcell_6t
XC4_114 BL114 BLB114 WL4 VDD VSS bitcell_6t
XC4_115 BL115 BLB115 WL4 VDD VSS bitcell_6t
XC4_116 BL116 BLB116 WL4 VDD VSS bitcell_6t
XC4_117 BL117 BLB117 WL4 VDD VSS bitcell_6t
XC4_118 BL118 BLB118 WL4 VDD VSS bitcell_6t
XC4_119 BL119 BLB119 WL4 VDD VSS bitcell_6t
XC4_120 BL120 BLB120 WL4 VDD VSS bitcell_6t
XC4_121 BL121 BLB121 WL4 VDD VSS bitcell_6t
XC4_122 BL122 BLB122 WL4 VDD VSS bitcell_6t
XC4_123 BL123 BLB123 WL4 VDD VSS bitcell_6t
XC4_124 BL124 BLB124 WL4 VDD VSS bitcell_6t
XC4_125 BL125 BLB125 WL4 VDD VSS bitcell_6t
XC4_126 BL126 BLB126 WL4 VDD VSS bitcell_6t
XC4_127 BL127 BLB127 WL4 VDD VSS bitcell_6t
XC5_0 BL0 BLB0 WL5 VDD VSS bitcell_6t
XC5_1 BL1 BLB1 WL5 VDD VSS bitcell_6t
XC5_2 BL2 BLB2 WL5 VDD VSS bitcell_6t
XC5_3 BL3 BLB3 WL5 VDD VSS bitcell_6t
XC5_4 BL4 BLB4 WL5 VDD VSS bitcell_6t
XC5_5 BL5 BLB5 WL5 VDD VSS bitcell_6t
XC5_6 BL6 BLB6 WL5 VDD VSS bitcell_6t
XC5_7 BL7 BLB7 WL5 VDD VSS bitcell_6t
XC5_8 BL8 BLB8 WL5 VDD VSS bitcell_6t
XC5_9 BL9 BLB9 WL5 VDD VSS bitcell_6t
XC5_10 BL10 BLB10 WL5 VDD VSS bitcell_6t
XC5_11 BL11 BLB11 WL5 VDD VSS bitcell_6t
XC5_12 BL12 BLB12 WL5 VDD VSS bitcell_6t
XC5_13 BL13 BLB13 WL5 VDD VSS bitcell_6t
XC5_14 BL14 BLB14 WL5 VDD VSS bitcell_6t
XC5_15 BL15 BLB15 WL5 VDD VSS bitcell_6t
XC5_16 BL16 BLB16 WL5 VDD VSS bitcell_6t
XC5_17 BL17 BLB17 WL5 VDD VSS bitcell_6t
XC5_18 BL18 BLB18 WL5 VDD VSS bitcell_6t
XC5_19 BL19 BLB19 WL5 VDD VSS bitcell_6t
XC5_20 BL20 BLB20 WL5 VDD VSS bitcell_6t
XC5_21 BL21 BLB21 WL5 VDD VSS bitcell_6t
XC5_22 BL22 BLB22 WL5 VDD VSS bitcell_6t
XC5_23 BL23 BLB23 WL5 VDD VSS bitcell_6t
XC5_24 BL24 BLB24 WL5 VDD VSS bitcell_6t
XC5_25 BL25 BLB25 WL5 VDD VSS bitcell_6t
XC5_26 BL26 BLB26 WL5 VDD VSS bitcell_6t
XC5_27 BL27 BLB27 WL5 VDD VSS bitcell_6t
XC5_28 BL28 BLB28 WL5 VDD VSS bitcell_6t
XC5_29 BL29 BLB29 WL5 VDD VSS bitcell_6t
XC5_30 BL30 BLB30 WL5 VDD VSS bitcell_6t
XC5_31 BL31 BLB31 WL5 VDD VSS bitcell_6t
XC5_32 BL32 BLB32 WL5 VDD VSS bitcell_6t
XC5_33 BL33 BLB33 WL5 VDD VSS bitcell_6t
XC5_34 BL34 BLB34 WL5 VDD VSS bitcell_6t
XC5_35 BL35 BLB35 WL5 VDD VSS bitcell_6t
XC5_36 BL36 BLB36 WL5 VDD VSS bitcell_6t
XC5_37 BL37 BLB37 WL5 VDD VSS bitcell_6t
XC5_38 BL38 BLB38 WL5 VDD VSS bitcell_6t
XC5_39 BL39 BLB39 WL5 VDD VSS bitcell_6t
XC5_40 BL40 BLB40 WL5 VDD VSS bitcell_6t
XC5_41 BL41 BLB41 WL5 VDD VSS bitcell_6t
XC5_42 BL42 BLB42 WL5 VDD VSS bitcell_6t
XC5_43 BL43 BLB43 WL5 VDD VSS bitcell_6t
XC5_44 BL44 BLB44 WL5 VDD VSS bitcell_6t
XC5_45 BL45 BLB45 WL5 VDD VSS bitcell_6t
XC5_46 BL46 BLB46 WL5 VDD VSS bitcell_6t
XC5_47 BL47 BLB47 WL5 VDD VSS bitcell_6t
XC5_48 BL48 BLB48 WL5 VDD VSS bitcell_6t
XC5_49 BL49 BLB49 WL5 VDD VSS bitcell_6t
XC5_50 BL50 BLB50 WL5 VDD VSS bitcell_6t
XC5_51 BL51 BLB51 WL5 VDD VSS bitcell_6t
XC5_52 BL52 BLB52 WL5 VDD VSS bitcell_6t
XC5_53 BL53 BLB53 WL5 VDD VSS bitcell_6t
XC5_54 BL54 BLB54 WL5 VDD VSS bitcell_6t
XC5_55 BL55 BLB55 WL5 VDD VSS bitcell_6t
XC5_56 BL56 BLB56 WL5 VDD VSS bitcell_6t
XC5_57 BL57 BLB57 WL5 VDD VSS bitcell_6t
XC5_58 BL58 BLB58 WL5 VDD VSS bitcell_6t
XC5_59 BL59 BLB59 WL5 VDD VSS bitcell_6t
XC5_60 BL60 BLB60 WL5 VDD VSS bitcell_6t
XC5_61 BL61 BLB61 WL5 VDD VSS bitcell_6t
XC5_62 BL62 BLB62 WL5 VDD VSS bitcell_6t
XC5_63 BL63 BLB63 WL5 VDD VSS bitcell_6t
XC5_64 BL64 BLB64 WL5 VDD VSS bitcell_6t
XC5_65 BL65 BLB65 WL5 VDD VSS bitcell_6t
XC5_66 BL66 BLB66 WL5 VDD VSS bitcell_6t
XC5_67 BL67 BLB67 WL5 VDD VSS bitcell_6t
XC5_68 BL68 BLB68 WL5 VDD VSS bitcell_6t
XC5_69 BL69 BLB69 WL5 VDD VSS bitcell_6t
XC5_70 BL70 BLB70 WL5 VDD VSS bitcell_6t
XC5_71 BL71 BLB71 WL5 VDD VSS bitcell_6t
XC5_72 BL72 BLB72 WL5 VDD VSS bitcell_6t
XC5_73 BL73 BLB73 WL5 VDD VSS bitcell_6t
XC5_74 BL74 BLB74 WL5 VDD VSS bitcell_6t
XC5_75 BL75 BLB75 WL5 VDD VSS bitcell_6t
XC5_76 BL76 BLB76 WL5 VDD VSS bitcell_6t
XC5_77 BL77 BLB77 WL5 VDD VSS bitcell_6t
XC5_78 BL78 BLB78 WL5 VDD VSS bitcell_6t
XC5_79 BL79 BLB79 WL5 VDD VSS bitcell_6t
XC5_80 BL80 BLB80 WL5 VDD VSS bitcell_6t
XC5_81 BL81 BLB81 WL5 VDD VSS bitcell_6t
XC5_82 BL82 BLB82 WL5 VDD VSS bitcell_6t
XC5_83 BL83 BLB83 WL5 VDD VSS bitcell_6t
XC5_84 BL84 BLB84 WL5 VDD VSS bitcell_6t
XC5_85 BL85 BLB85 WL5 VDD VSS bitcell_6t
XC5_86 BL86 BLB86 WL5 VDD VSS bitcell_6t
XC5_87 BL87 BLB87 WL5 VDD VSS bitcell_6t
XC5_88 BL88 BLB88 WL5 VDD VSS bitcell_6t
XC5_89 BL89 BLB89 WL5 VDD VSS bitcell_6t
XC5_90 BL90 BLB90 WL5 VDD VSS bitcell_6t
XC5_91 BL91 BLB91 WL5 VDD VSS bitcell_6t
XC5_92 BL92 BLB92 WL5 VDD VSS bitcell_6t
XC5_93 BL93 BLB93 WL5 VDD VSS bitcell_6t
XC5_94 BL94 BLB94 WL5 VDD VSS bitcell_6t
XC5_95 BL95 BLB95 WL5 VDD VSS bitcell_6t
XC5_96 BL96 BLB96 WL5 VDD VSS bitcell_6t
XC5_97 BL97 BLB97 WL5 VDD VSS bitcell_6t
XC5_98 BL98 BLB98 WL5 VDD VSS bitcell_6t
XC5_99 BL99 BLB99 WL5 VDD VSS bitcell_6t
XC5_100 BL100 BLB100 WL5 VDD VSS bitcell_6t
XC5_101 BL101 BLB101 WL5 VDD VSS bitcell_6t
XC5_102 BL102 BLB102 WL5 VDD VSS bitcell_6t
XC5_103 BL103 BLB103 WL5 VDD VSS bitcell_6t
XC5_104 BL104 BLB104 WL5 VDD VSS bitcell_6t
XC5_105 BL105 BLB105 WL5 VDD VSS bitcell_6t
XC5_106 BL106 BLB106 WL5 VDD VSS bitcell_6t
XC5_107 BL107 BLB107 WL5 VDD VSS bitcell_6t
XC5_108 BL108 BLB108 WL5 VDD VSS bitcell_6t
XC5_109 BL109 BLB109 WL5 VDD VSS bitcell_6t
XC5_110 BL110 BLB110 WL5 VDD VSS bitcell_6t
XC5_111 BL111 BLB111 WL5 VDD VSS bitcell_6t
XC5_112 BL112 BLB112 WL5 VDD VSS bitcell_6t
XC5_113 BL113 BLB113 WL5 VDD VSS bitcell_6t
XC5_114 BL114 BLB114 WL5 VDD VSS bitcell_6t
XC5_115 BL115 BLB115 WL5 VDD VSS bitcell_6t
XC5_116 BL116 BLB116 WL5 VDD VSS bitcell_6t
XC5_117 BL117 BLB117 WL5 VDD VSS bitcell_6t
XC5_118 BL118 BLB118 WL5 VDD VSS bitcell_6t
XC5_119 BL119 BLB119 WL5 VDD VSS bitcell_6t
XC5_120 BL120 BLB120 WL5 VDD VSS bitcell_6t
XC5_121 BL121 BLB121 WL5 VDD VSS bitcell_6t
XC5_122 BL122 BLB122 WL5 VDD VSS bitcell_6t
XC5_123 BL123 BLB123 WL5 VDD VSS bitcell_6t
XC5_124 BL124 BLB124 WL5 VDD VSS bitcell_6t
XC5_125 BL125 BLB125 WL5 VDD VSS bitcell_6t
XC5_126 BL126 BLB126 WL5 VDD VSS bitcell_6t
XC5_127 BL127 BLB127 WL5 VDD VSS bitcell_6t
XC6_0 BL0 BLB0 WL6 VDD VSS bitcell_6t
XC6_1 BL1 BLB1 WL6 VDD VSS bitcell_6t
XC6_2 BL2 BLB2 WL6 VDD VSS bitcell_6t
XC6_3 BL3 BLB3 WL6 VDD VSS bitcell_6t
XC6_4 BL4 BLB4 WL6 VDD VSS bitcell_6t
XC6_5 BL5 BLB5 WL6 VDD VSS bitcell_6t
XC6_6 BL6 BLB6 WL6 VDD VSS bitcell_6t
XC6_7 BL7 BLB7 WL6 VDD VSS bitcell_6t
XC6_8 BL8 BLB8 WL6 VDD VSS bitcell_6t
XC6_9 BL9 BLB9 WL6 VDD VSS bitcell_6t
XC6_10 BL10 BLB10 WL6 VDD VSS bitcell_6t
XC6_11 BL11 BLB11 WL6 VDD VSS bitcell_6t
XC6_12 BL12 BLB12 WL6 VDD VSS bitcell_6t
XC6_13 BL13 BLB13 WL6 VDD VSS bitcell_6t
XC6_14 BL14 BLB14 WL6 VDD VSS bitcell_6t
XC6_15 BL15 BLB15 WL6 VDD VSS bitcell_6t
XC6_16 BL16 BLB16 WL6 VDD VSS bitcell_6t
XC6_17 BL17 BLB17 WL6 VDD VSS bitcell_6t
XC6_18 BL18 BLB18 WL6 VDD VSS bitcell_6t
XC6_19 BL19 BLB19 WL6 VDD VSS bitcell_6t
XC6_20 BL20 BLB20 WL6 VDD VSS bitcell_6t
XC6_21 BL21 BLB21 WL6 VDD VSS bitcell_6t
XC6_22 BL22 BLB22 WL6 VDD VSS bitcell_6t
XC6_23 BL23 BLB23 WL6 VDD VSS bitcell_6t
XC6_24 BL24 BLB24 WL6 VDD VSS bitcell_6t
XC6_25 BL25 BLB25 WL6 VDD VSS bitcell_6t
XC6_26 BL26 BLB26 WL6 VDD VSS bitcell_6t
XC6_27 BL27 BLB27 WL6 VDD VSS bitcell_6t
XC6_28 BL28 BLB28 WL6 VDD VSS bitcell_6t
XC6_29 BL29 BLB29 WL6 VDD VSS bitcell_6t
XC6_30 BL30 BLB30 WL6 VDD VSS bitcell_6t
XC6_31 BL31 BLB31 WL6 VDD VSS bitcell_6t
XC6_32 BL32 BLB32 WL6 VDD VSS bitcell_6t
XC6_33 BL33 BLB33 WL6 VDD VSS bitcell_6t
XC6_34 BL34 BLB34 WL6 VDD VSS bitcell_6t
XC6_35 BL35 BLB35 WL6 VDD VSS bitcell_6t
XC6_36 BL36 BLB36 WL6 VDD VSS bitcell_6t
XC6_37 BL37 BLB37 WL6 VDD VSS bitcell_6t
XC6_38 BL38 BLB38 WL6 VDD VSS bitcell_6t
XC6_39 BL39 BLB39 WL6 VDD VSS bitcell_6t
XC6_40 BL40 BLB40 WL6 VDD VSS bitcell_6t
XC6_41 BL41 BLB41 WL6 VDD VSS bitcell_6t
XC6_42 BL42 BLB42 WL6 VDD VSS bitcell_6t
XC6_43 BL43 BLB43 WL6 VDD VSS bitcell_6t
XC6_44 BL44 BLB44 WL6 VDD VSS bitcell_6t
XC6_45 BL45 BLB45 WL6 VDD VSS bitcell_6t
XC6_46 BL46 BLB46 WL6 VDD VSS bitcell_6t
XC6_47 BL47 BLB47 WL6 VDD VSS bitcell_6t
XC6_48 BL48 BLB48 WL6 VDD VSS bitcell_6t
XC6_49 BL49 BLB49 WL6 VDD VSS bitcell_6t
XC6_50 BL50 BLB50 WL6 VDD VSS bitcell_6t
XC6_51 BL51 BLB51 WL6 VDD VSS bitcell_6t
XC6_52 BL52 BLB52 WL6 VDD VSS bitcell_6t
XC6_53 BL53 BLB53 WL6 VDD VSS bitcell_6t
XC6_54 BL54 BLB54 WL6 VDD VSS bitcell_6t
XC6_55 BL55 BLB55 WL6 VDD VSS bitcell_6t
XC6_56 BL56 BLB56 WL6 VDD VSS bitcell_6t
XC6_57 BL57 BLB57 WL6 VDD VSS bitcell_6t
XC6_58 BL58 BLB58 WL6 VDD VSS bitcell_6t
XC6_59 BL59 BLB59 WL6 VDD VSS bitcell_6t
XC6_60 BL60 BLB60 WL6 VDD VSS bitcell_6t
XC6_61 BL61 BLB61 WL6 VDD VSS bitcell_6t
XC6_62 BL62 BLB62 WL6 VDD VSS bitcell_6t
XC6_63 BL63 BLB63 WL6 VDD VSS bitcell_6t
XC6_64 BL64 BLB64 WL6 VDD VSS bitcell_6t
XC6_65 BL65 BLB65 WL6 VDD VSS bitcell_6t
XC6_66 BL66 BLB66 WL6 VDD VSS bitcell_6t
XC6_67 BL67 BLB67 WL6 VDD VSS bitcell_6t
XC6_68 BL68 BLB68 WL6 VDD VSS bitcell_6t
XC6_69 BL69 BLB69 WL6 VDD VSS bitcell_6t
XC6_70 BL70 BLB70 WL6 VDD VSS bitcell_6t
XC6_71 BL71 BLB71 WL6 VDD VSS bitcell_6t
XC6_72 BL72 BLB72 WL6 VDD VSS bitcell_6t
XC6_73 BL73 BLB73 WL6 VDD VSS bitcell_6t
XC6_74 BL74 BLB74 WL6 VDD VSS bitcell_6t
XC6_75 BL75 BLB75 WL6 VDD VSS bitcell_6t
XC6_76 BL76 BLB76 WL6 VDD VSS bitcell_6t
XC6_77 BL77 BLB77 WL6 VDD VSS bitcell_6t
XC6_78 BL78 BLB78 WL6 VDD VSS bitcell_6t
XC6_79 BL79 BLB79 WL6 VDD VSS bitcell_6t
XC6_80 BL80 BLB80 WL6 VDD VSS bitcell_6t
XC6_81 BL81 BLB81 WL6 VDD VSS bitcell_6t
XC6_82 BL82 BLB82 WL6 VDD VSS bitcell_6t
XC6_83 BL83 BLB83 WL6 VDD VSS bitcell_6t
XC6_84 BL84 BLB84 WL6 VDD VSS bitcell_6t
XC6_85 BL85 BLB85 WL6 VDD VSS bitcell_6t
XC6_86 BL86 BLB86 WL6 VDD VSS bitcell_6t
XC6_87 BL87 BLB87 WL6 VDD VSS bitcell_6t
XC6_88 BL88 BLB88 WL6 VDD VSS bitcell_6t
XC6_89 BL89 BLB89 WL6 VDD VSS bitcell_6t
XC6_90 BL90 BLB90 WL6 VDD VSS bitcell_6t
XC6_91 BL91 BLB91 WL6 VDD VSS bitcell_6t
XC6_92 BL92 BLB92 WL6 VDD VSS bitcell_6t
XC6_93 BL93 BLB93 WL6 VDD VSS bitcell_6t
XC6_94 BL94 BLB94 WL6 VDD VSS bitcell_6t
XC6_95 BL95 BLB95 WL6 VDD VSS bitcell_6t
XC6_96 BL96 BLB96 WL6 VDD VSS bitcell_6t
XC6_97 BL97 BLB97 WL6 VDD VSS bitcell_6t
XC6_98 BL98 BLB98 WL6 VDD VSS bitcell_6t
XC6_99 BL99 BLB99 WL6 VDD VSS bitcell_6t
XC6_100 BL100 BLB100 WL6 VDD VSS bitcell_6t
XC6_101 BL101 BLB101 WL6 VDD VSS bitcell_6t
XC6_102 BL102 BLB102 WL6 VDD VSS bitcell_6t
XC6_103 BL103 BLB103 WL6 VDD VSS bitcell_6t
XC6_104 BL104 BLB104 WL6 VDD VSS bitcell_6t
XC6_105 BL105 BLB105 WL6 VDD VSS bitcell_6t
XC6_106 BL106 BLB106 WL6 VDD VSS bitcell_6t
XC6_107 BL107 BLB107 WL6 VDD VSS bitcell_6t
XC6_108 BL108 BLB108 WL6 VDD VSS bitcell_6t
XC6_109 BL109 BLB109 WL6 VDD VSS bitcell_6t
XC6_110 BL110 BLB110 WL6 VDD VSS bitcell_6t
XC6_111 BL111 BLB111 WL6 VDD VSS bitcell_6t
XC6_112 BL112 BLB112 WL6 VDD VSS bitcell_6t
XC6_113 BL113 BLB113 WL6 VDD VSS bitcell_6t
XC6_114 BL114 BLB114 WL6 VDD VSS bitcell_6t
XC6_115 BL115 BLB115 WL6 VDD VSS bitcell_6t
XC6_116 BL116 BLB116 WL6 VDD VSS bitcell_6t
XC6_117 BL117 BLB117 WL6 VDD VSS bitcell_6t
XC6_118 BL118 BLB118 WL6 VDD VSS bitcell_6t
XC6_119 BL119 BLB119 WL6 VDD VSS bitcell_6t
XC6_120 BL120 BLB120 WL6 VDD VSS bitcell_6t
XC6_121 BL121 BLB121 WL6 VDD VSS bitcell_6t
XC6_122 BL122 BLB122 WL6 VDD VSS bitcell_6t
XC6_123 BL123 BLB123 WL6 VDD VSS bitcell_6t
XC6_124 BL124 BLB124 WL6 VDD VSS bitcell_6t
XC6_125 BL125 BLB125 WL6 VDD VSS bitcell_6t
XC6_126 BL126 BLB126 WL6 VDD VSS bitcell_6t
XC6_127 BL127 BLB127 WL6 VDD VSS bitcell_6t
XC7_0 BL0 BLB0 WL7 VDD VSS bitcell_6t
XC7_1 BL1 BLB1 WL7 VDD VSS bitcell_6t
XC7_2 BL2 BLB2 WL7 VDD VSS bitcell_6t
XC7_3 BL3 BLB3 WL7 VDD VSS bitcell_6t
XC7_4 BL4 BLB4 WL7 VDD VSS bitcell_6t
XC7_5 BL5 BLB5 WL7 VDD VSS bitcell_6t
XC7_6 BL6 BLB6 WL7 VDD VSS bitcell_6t
XC7_7 BL7 BLB7 WL7 VDD VSS bitcell_6t
XC7_8 BL8 BLB8 WL7 VDD VSS bitcell_6t
XC7_9 BL9 BLB9 WL7 VDD VSS bitcell_6t
XC7_10 BL10 BLB10 WL7 VDD VSS bitcell_6t
XC7_11 BL11 BLB11 WL7 VDD VSS bitcell_6t
XC7_12 BL12 BLB12 WL7 VDD VSS bitcell_6t
XC7_13 BL13 BLB13 WL7 VDD VSS bitcell_6t
XC7_14 BL14 BLB14 WL7 VDD VSS bitcell_6t
XC7_15 BL15 BLB15 WL7 VDD VSS bitcell_6t
XC7_16 BL16 BLB16 WL7 VDD VSS bitcell_6t
XC7_17 BL17 BLB17 WL7 VDD VSS bitcell_6t
XC7_18 BL18 BLB18 WL7 VDD VSS bitcell_6t
XC7_19 BL19 BLB19 WL7 VDD VSS bitcell_6t
XC7_20 BL20 BLB20 WL7 VDD VSS bitcell_6t
XC7_21 BL21 BLB21 WL7 VDD VSS bitcell_6t
XC7_22 BL22 BLB22 WL7 VDD VSS bitcell_6t
XC7_23 BL23 BLB23 WL7 VDD VSS bitcell_6t
XC7_24 BL24 BLB24 WL7 VDD VSS bitcell_6t
XC7_25 BL25 BLB25 WL7 VDD VSS bitcell_6t
XC7_26 BL26 BLB26 WL7 VDD VSS bitcell_6t
XC7_27 BL27 BLB27 WL7 VDD VSS bitcell_6t
XC7_28 BL28 BLB28 WL7 VDD VSS bitcell_6t
XC7_29 BL29 BLB29 WL7 VDD VSS bitcell_6t
XC7_30 BL30 BLB30 WL7 VDD VSS bitcell_6t
XC7_31 BL31 BLB31 WL7 VDD VSS bitcell_6t
XC7_32 BL32 BLB32 WL7 VDD VSS bitcell_6t
XC7_33 BL33 BLB33 WL7 VDD VSS bitcell_6t
XC7_34 BL34 BLB34 WL7 VDD VSS bitcell_6t
XC7_35 BL35 BLB35 WL7 VDD VSS bitcell_6t
XC7_36 BL36 BLB36 WL7 VDD VSS bitcell_6t
XC7_37 BL37 BLB37 WL7 VDD VSS bitcell_6t
XC7_38 BL38 BLB38 WL7 VDD VSS bitcell_6t
XC7_39 BL39 BLB39 WL7 VDD VSS bitcell_6t
XC7_40 BL40 BLB40 WL7 VDD VSS bitcell_6t
XC7_41 BL41 BLB41 WL7 VDD VSS bitcell_6t
XC7_42 BL42 BLB42 WL7 VDD VSS bitcell_6t
XC7_43 BL43 BLB43 WL7 VDD VSS bitcell_6t
XC7_44 BL44 BLB44 WL7 VDD VSS bitcell_6t
XC7_45 BL45 BLB45 WL7 VDD VSS bitcell_6t
XC7_46 BL46 BLB46 WL7 VDD VSS bitcell_6t
XC7_47 BL47 BLB47 WL7 VDD VSS bitcell_6t
XC7_48 BL48 BLB48 WL7 VDD VSS bitcell_6t
XC7_49 BL49 BLB49 WL7 VDD VSS bitcell_6t
XC7_50 BL50 BLB50 WL7 VDD VSS bitcell_6t
XC7_51 BL51 BLB51 WL7 VDD VSS bitcell_6t
XC7_52 BL52 BLB52 WL7 VDD VSS bitcell_6t
XC7_53 BL53 BLB53 WL7 VDD VSS bitcell_6t
XC7_54 BL54 BLB54 WL7 VDD VSS bitcell_6t
XC7_55 BL55 BLB55 WL7 VDD VSS bitcell_6t
XC7_56 BL56 BLB56 WL7 VDD VSS bitcell_6t
XC7_57 BL57 BLB57 WL7 VDD VSS bitcell_6t
XC7_58 BL58 BLB58 WL7 VDD VSS bitcell_6t
XC7_59 BL59 BLB59 WL7 VDD VSS bitcell_6t
XC7_60 BL60 BLB60 WL7 VDD VSS bitcell_6t
XC7_61 BL61 BLB61 WL7 VDD VSS bitcell_6t
XC7_62 BL62 BLB62 WL7 VDD VSS bitcell_6t
XC7_63 BL63 BLB63 WL7 VDD VSS bitcell_6t
XC7_64 BL64 BLB64 WL7 VDD VSS bitcell_6t
XC7_65 BL65 BLB65 WL7 VDD VSS bitcell_6t
XC7_66 BL66 BLB66 WL7 VDD VSS bitcell_6t
XC7_67 BL67 BLB67 WL7 VDD VSS bitcell_6t
XC7_68 BL68 BLB68 WL7 VDD VSS bitcell_6t
XC7_69 BL69 BLB69 WL7 VDD VSS bitcell_6t
XC7_70 BL70 BLB70 WL7 VDD VSS bitcell_6t
XC7_71 BL71 BLB71 WL7 VDD VSS bitcell_6t
XC7_72 BL72 BLB72 WL7 VDD VSS bitcell_6t
XC7_73 BL73 BLB73 WL7 VDD VSS bitcell_6t
XC7_74 BL74 BLB74 WL7 VDD VSS bitcell_6t
XC7_75 BL75 BLB75 WL7 VDD VSS bitcell_6t
XC7_76 BL76 BLB76 WL7 VDD VSS bitcell_6t
XC7_77 BL77 BLB77 WL7 VDD VSS bitcell_6t
XC7_78 BL78 BLB78 WL7 VDD VSS bitcell_6t
XC7_79 BL79 BLB79 WL7 VDD VSS bitcell_6t
XC7_80 BL80 BLB80 WL7 VDD VSS bitcell_6t
XC7_81 BL81 BLB81 WL7 VDD VSS bitcell_6t
XC7_82 BL82 BLB82 WL7 VDD VSS bitcell_6t
XC7_83 BL83 BLB83 WL7 VDD VSS bitcell_6t
XC7_84 BL84 BLB84 WL7 VDD VSS bitcell_6t
XC7_85 BL85 BLB85 WL7 VDD VSS bitcell_6t
XC7_86 BL86 BLB86 WL7 VDD VSS bitcell_6t
XC7_87 BL87 BLB87 WL7 VDD VSS bitcell_6t
XC7_88 BL88 BLB88 WL7 VDD VSS bitcell_6t
XC7_89 BL89 BLB89 WL7 VDD VSS bitcell_6t
XC7_90 BL90 BLB90 WL7 VDD VSS bitcell_6t
XC7_91 BL91 BLB91 WL7 VDD VSS bitcell_6t
XC7_92 BL92 BLB92 WL7 VDD VSS bitcell_6t
XC7_93 BL93 BLB93 WL7 VDD VSS bitcell_6t
XC7_94 BL94 BLB94 WL7 VDD VSS bitcell_6t
XC7_95 BL95 BLB95 WL7 VDD VSS bitcell_6t
XC7_96 BL96 BLB96 WL7 VDD VSS bitcell_6t
XC7_97 BL97 BLB97 WL7 VDD VSS bitcell_6t
XC7_98 BL98 BLB98 WL7 VDD VSS bitcell_6t
XC7_99 BL99 BLB99 WL7 VDD VSS bitcell_6t
XC7_100 BL100 BLB100 WL7 VDD VSS bitcell_6t
XC7_101 BL101 BLB101 WL7 VDD VSS bitcell_6t
XC7_102 BL102 BLB102 WL7 VDD VSS bitcell_6t
XC7_103 BL103 BLB103 WL7 VDD VSS bitcell_6t
XC7_104 BL104 BLB104 WL7 VDD VSS bitcell_6t
XC7_105 BL105 BLB105 WL7 VDD VSS bitcell_6t
XC7_106 BL106 BLB106 WL7 VDD VSS bitcell_6t
XC7_107 BL107 BLB107 WL7 VDD VSS bitcell_6t
XC7_108 BL108 BLB108 WL7 VDD VSS bitcell_6t
XC7_109 BL109 BLB109 WL7 VDD VSS bitcell_6t
XC7_110 BL110 BLB110 WL7 VDD VSS bitcell_6t
XC7_111 BL111 BLB111 WL7 VDD VSS bitcell_6t
XC7_112 BL112 BLB112 WL7 VDD VSS bitcell_6t
XC7_113 BL113 BLB113 WL7 VDD VSS bitcell_6t
XC7_114 BL114 BLB114 WL7 VDD VSS bitcell_6t
XC7_115 BL115 BLB115 WL7 VDD VSS bitcell_6t
XC7_116 BL116 BLB116 WL7 VDD VSS bitcell_6t
XC7_117 BL117 BLB117 WL7 VDD VSS bitcell_6t
XC7_118 BL118 BLB118 WL7 VDD VSS bitcell_6t
XC7_119 BL119 BLB119 WL7 VDD VSS bitcell_6t
XC7_120 BL120 BLB120 WL7 VDD VSS bitcell_6t
XC7_121 BL121 BLB121 WL7 VDD VSS bitcell_6t
XC7_122 BL122 BLB122 WL7 VDD VSS bitcell_6t
XC7_123 BL123 BLB123 WL7 VDD VSS bitcell_6t
XC7_124 BL124 BLB124 WL7 VDD VSS bitcell_6t
XC7_125 BL125 BLB125 WL7 VDD VSS bitcell_6t
XC7_126 BL126 BLB126 WL7 VDD VSS bitcell_6t
XC7_127 BL127 BLB127 WL7 VDD VSS bitcell_6t
XC8_0 BL0 BLB0 WL8 VDD VSS bitcell_6t
XC8_1 BL1 BLB1 WL8 VDD VSS bitcell_6t
XC8_2 BL2 BLB2 WL8 VDD VSS bitcell_6t
XC8_3 BL3 BLB3 WL8 VDD VSS bitcell_6t
XC8_4 BL4 BLB4 WL8 VDD VSS bitcell_6t
XC8_5 BL5 BLB5 WL8 VDD VSS bitcell_6t
XC8_6 BL6 BLB6 WL8 VDD VSS bitcell_6t
XC8_7 BL7 BLB7 WL8 VDD VSS bitcell_6t
XC8_8 BL8 BLB8 WL8 VDD VSS bitcell_6t
XC8_9 BL9 BLB9 WL8 VDD VSS bitcell_6t
XC8_10 BL10 BLB10 WL8 VDD VSS bitcell_6t
XC8_11 BL11 BLB11 WL8 VDD VSS bitcell_6t
XC8_12 BL12 BLB12 WL8 VDD VSS bitcell_6t
XC8_13 BL13 BLB13 WL8 VDD VSS bitcell_6t
XC8_14 BL14 BLB14 WL8 VDD VSS bitcell_6t
XC8_15 BL15 BLB15 WL8 VDD VSS bitcell_6t
XC8_16 BL16 BLB16 WL8 VDD VSS bitcell_6t
XC8_17 BL17 BLB17 WL8 VDD VSS bitcell_6t
XC8_18 BL18 BLB18 WL8 VDD VSS bitcell_6t
XC8_19 BL19 BLB19 WL8 VDD VSS bitcell_6t
XC8_20 BL20 BLB20 WL8 VDD VSS bitcell_6t
XC8_21 BL21 BLB21 WL8 VDD VSS bitcell_6t
XC8_22 BL22 BLB22 WL8 VDD VSS bitcell_6t
XC8_23 BL23 BLB23 WL8 VDD VSS bitcell_6t
XC8_24 BL24 BLB24 WL8 VDD VSS bitcell_6t
XC8_25 BL25 BLB25 WL8 VDD VSS bitcell_6t
XC8_26 BL26 BLB26 WL8 VDD VSS bitcell_6t
XC8_27 BL27 BLB27 WL8 VDD VSS bitcell_6t
XC8_28 BL28 BLB28 WL8 VDD VSS bitcell_6t
XC8_29 BL29 BLB29 WL8 VDD VSS bitcell_6t
XC8_30 BL30 BLB30 WL8 VDD VSS bitcell_6t
XC8_31 BL31 BLB31 WL8 VDD VSS bitcell_6t
XC8_32 BL32 BLB32 WL8 VDD VSS bitcell_6t
XC8_33 BL33 BLB33 WL8 VDD VSS bitcell_6t
XC8_34 BL34 BLB34 WL8 VDD VSS bitcell_6t
XC8_35 BL35 BLB35 WL8 VDD VSS bitcell_6t
XC8_36 BL36 BLB36 WL8 VDD VSS bitcell_6t
XC8_37 BL37 BLB37 WL8 VDD VSS bitcell_6t
XC8_38 BL38 BLB38 WL8 VDD VSS bitcell_6t
XC8_39 BL39 BLB39 WL8 VDD VSS bitcell_6t
XC8_40 BL40 BLB40 WL8 VDD VSS bitcell_6t
XC8_41 BL41 BLB41 WL8 VDD VSS bitcell_6t
XC8_42 BL42 BLB42 WL8 VDD VSS bitcell_6t
XC8_43 BL43 BLB43 WL8 VDD VSS bitcell_6t
XC8_44 BL44 BLB44 WL8 VDD VSS bitcell_6t
XC8_45 BL45 BLB45 WL8 VDD VSS bitcell_6t
XC8_46 BL46 BLB46 WL8 VDD VSS bitcell_6t
XC8_47 BL47 BLB47 WL8 VDD VSS bitcell_6t
XC8_48 BL48 BLB48 WL8 VDD VSS bitcell_6t
XC8_49 BL49 BLB49 WL8 VDD VSS bitcell_6t
XC8_50 BL50 BLB50 WL8 VDD VSS bitcell_6t
XC8_51 BL51 BLB51 WL8 VDD VSS bitcell_6t
XC8_52 BL52 BLB52 WL8 VDD VSS bitcell_6t
XC8_53 BL53 BLB53 WL8 VDD VSS bitcell_6t
XC8_54 BL54 BLB54 WL8 VDD VSS bitcell_6t
XC8_55 BL55 BLB55 WL8 VDD VSS bitcell_6t
XC8_56 BL56 BLB56 WL8 VDD VSS bitcell_6t
XC8_57 BL57 BLB57 WL8 VDD VSS bitcell_6t
XC8_58 BL58 BLB58 WL8 VDD VSS bitcell_6t
XC8_59 BL59 BLB59 WL8 VDD VSS bitcell_6t
XC8_60 BL60 BLB60 WL8 VDD VSS bitcell_6t
XC8_61 BL61 BLB61 WL8 VDD VSS bitcell_6t
XC8_62 BL62 BLB62 WL8 VDD VSS bitcell_6t
XC8_63 BL63 BLB63 WL8 VDD VSS bitcell_6t
XC8_64 BL64 BLB64 WL8 VDD VSS bitcell_6t
XC8_65 BL65 BLB65 WL8 VDD VSS bitcell_6t
XC8_66 BL66 BLB66 WL8 VDD VSS bitcell_6t
XC8_67 BL67 BLB67 WL8 VDD VSS bitcell_6t
XC8_68 BL68 BLB68 WL8 VDD VSS bitcell_6t
XC8_69 BL69 BLB69 WL8 VDD VSS bitcell_6t
XC8_70 BL70 BLB70 WL8 VDD VSS bitcell_6t
XC8_71 BL71 BLB71 WL8 VDD VSS bitcell_6t
XC8_72 BL72 BLB72 WL8 VDD VSS bitcell_6t
XC8_73 BL73 BLB73 WL8 VDD VSS bitcell_6t
XC8_74 BL74 BLB74 WL8 VDD VSS bitcell_6t
XC8_75 BL75 BLB75 WL8 VDD VSS bitcell_6t
XC8_76 BL76 BLB76 WL8 VDD VSS bitcell_6t
XC8_77 BL77 BLB77 WL8 VDD VSS bitcell_6t
XC8_78 BL78 BLB78 WL8 VDD VSS bitcell_6t
XC8_79 BL79 BLB79 WL8 VDD VSS bitcell_6t
XC8_80 BL80 BLB80 WL8 VDD VSS bitcell_6t
XC8_81 BL81 BLB81 WL8 VDD VSS bitcell_6t
XC8_82 BL82 BLB82 WL8 VDD VSS bitcell_6t
XC8_83 BL83 BLB83 WL8 VDD VSS bitcell_6t
XC8_84 BL84 BLB84 WL8 VDD VSS bitcell_6t
XC8_85 BL85 BLB85 WL8 VDD VSS bitcell_6t
XC8_86 BL86 BLB86 WL8 VDD VSS bitcell_6t
XC8_87 BL87 BLB87 WL8 VDD VSS bitcell_6t
XC8_88 BL88 BLB88 WL8 VDD VSS bitcell_6t
XC8_89 BL89 BLB89 WL8 VDD VSS bitcell_6t
XC8_90 BL90 BLB90 WL8 VDD VSS bitcell_6t
XC8_91 BL91 BLB91 WL8 VDD VSS bitcell_6t
XC8_92 BL92 BLB92 WL8 VDD VSS bitcell_6t
XC8_93 BL93 BLB93 WL8 VDD VSS bitcell_6t
XC8_94 BL94 BLB94 WL8 VDD VSS bitcell_6t
XC8_95 BL95 BLB95 WL8 VDD VSS bitcell_6t
XC8_96 BL96 BLB96 WL8 VDD VSS bitcell_6t
XC8_97 BL97 BLB97 WL8 VDD VSS bitcell_6t
XC8_98 BL98 BLB98 WL8 VDD VSS bitcell_6t
XC8_99 BL99 BLB99 WL8 VDD VSS bitcell_6t
XC8_100 BL100 BLB100 WL8 VDD VSS bitcell_6t
XC8_101 BL101 BLB101 WL8 VDD VSS bitcell_6t
XC8_102 BL102 BLB102 WL8 VDD VSS bitcell_6t
XC8_103 BL103 BLB103 WL8 VDD VSS bitcell_6t
XC8_104 BL104 BLB104 WL8 VDD VSS bitcell_6t
XC8_105 BL105 BLB105 WL8 VDD VSS bitcell_6t
XC8_106 BL106 BLB106 WL8 VDD VSS bitcell_6t
XC8_107 BL107 BLB107 WL8 VDD VSS bitcell_6t
XC8_108 BL108 BLB108 WL8 VDD VSS bitcell_6t
XC8_109 BL109 BLB109 WL8 VDD VSS bitcell_6t
XC8_110 BL110 BLB110 WL8 VDD VSS bitcell_6t
XC8_111 BL111 BLB111 WL8 VDD VSS bitcell_6t
XC8_112 BL112 BLB112 WL8 VDD VSS bitcell_6t
XC8_113 BL113 BLB113 WL8 VDD VSS bitcell_6t
XC8_114 BL114 BLB114 WL8 VDD VSS bitcell_6t
XC8_115 BL115 BLB115 WL8 VDD VSS bitcell_6t
XC8_116 BL116 BLB116 WL8 VDD VSS bitcell_6t
XC8_117 BL117 BLB117 WL8 VDD VSS bitcell_6t
XC8_118 BL118 BLB118 WL8 VDD VSS bitcell_6t
XC8_119 BL119 BLB119 WL8 VDD VSS bitcell_6t
XC8_120 BL120 BLB120 WL8 VDD VSS bitcell_6t
XC8_121 BL121 BLB121 WL8 VDD VSS bitcell_6t
XC8_122 BL122 BLB122 WL8 VDD VSS bitcell_6t
XC8_123 BL123 BLB123 WL8 VDD VSS bitcell_6t
XC8_124 BL124 BLB124 WL8 VDD VSS bitcell_6t
XC8_125 BL125 BLB125 WL8 VDD VSS bitcell_6t
XC8_126 BL126 BLB126 WL8 VDD VSS bitcell_6t
XC8_127 BL127 BLB127 WL8 VDD VSS bitcell_6t
XC9_0 BL0 BLB0 WL9 VDD VSS bitcell_6t
XC9_1 BL1 BLB1 WL9 VDD VSS bitcell_6t
XC9_2 BL2 BLB2 WL9 VDD VSS bitcell_6t
XC9_3 BL3 BLB3 WL9 VDD VSS bitcell_6t
XC9_4 BL4 BLB4 WL9 VDD VSS bitcell_6t
XC9_5 BL5 BLB5 WL9 VDD VSS bitcell_6t
XC9_6 BL6 BLB6 WL9 VDD VSS bitcell_6t
XC9_7 BL7 BLB7 WL9 VDD VSS bitcell_6t
XC9_8 BL8 BLB8 WL9 VDD VSS bitcell_6t
XC9_9 BL9 BLB9 WL9 VDD VSS bitcell_6t
XC9_10 BL10 BLB10 WL9 VDD VSS bitcell_6t
XC9_11 BL11 BLB11 WL9 VDD VSS bitcell_6t
XC9_12 BL12 BLB12 WL9 VDD VSS bitcell_6t
XC9_13 BL13 BLB13 WL9 VDD VSS bitcell_6t
XC9_14 BL14 BLB14 WL9 VDD VSS bitcell_6t
XC9_15 BL15 BLB15 WL9 VDD VSS bitcell_6t
XC9_16 BL16 BLB16 WL9 VDD VSS bitcell_6t
XC9_17 BL17 BLB17 WL9 VDD VSS bitcell_6t
XC9_18 BL18 BLB18 WL9 VDD VSS bitcell_6t
XC9_19 BL19 BLB19 WL9 VDD VSS bitcell_6t
XC9_20 BL20 BLB20 WL9 VDD VSS bitcell_6t
XC9_21 BL21 BLB21 WL9 VDD VSS bitcell_6t
XC9_22 BL22 BLB22 WL9 VDD VSS bitcell_6t
XC9_23 BL23 BLB23 WL9 VDD VSS bitcell_6t
XC9_24 BL24 BLB24 WL9 VDD VSS bitcell_6t
XC9_25 BL25 BLB25 WL9 VDD VSS bitcell_6t
XC9_26 BL26 BLB26 WL9 VDD VSS bitcell_6t
XC9_27 BL27 BLB27 WL9 VDD VSS bitcell_6t
XC9_28 BL28 BLB28 WL9 VDD VSS bitcell_6t
XC9_29 BL29 BLB29 WL9 VDD VSS bitcell_6t
XC9_30 BL30 BLB30 WL9 VDD VSS bitcell_6t
XC9_31 BL31 BLB31 WL9 VDD VSS bitcell_6t
XC9_32 BL32 BLB32 WL9 VDD VSS bitcell_6t
XC9_33 BL33 BLB33 WL9 VDD VSS bitcell_6t
XC9_34 BL34 BLB34 WL9 VDD VSS bitcell_6t
XC9_35 BL35 BLB35 WL9 VDD VSS bitcell_6t
XC9_36 BL36 BLB36 WL9 VDD VSS bitcell_6t
XC9_37 BL37 BLB37 WL9 VDD VSS bitcell_6t
XC9_38 BL38 BLB38 WL9 VDD VSS bitcell_6t
XC9_39 BL39 BLB39 WL9 VDD VSS bitcell_6t
XC9_40 BL40 BLB40 WL9 VDD VSS bitcell_6t
XC9_41 BL41 BLB41 WL9 VDD VSS bitcell_6t
XC9_42 BL42 BLB42 WL9 VDD VSS bitcell_6t
XC9_43 BL43 BLB43 WL9 VDD VSS bitcell_6t
XC9_44 BL44 BLB44 WL9 VDD VSS bitcell_6t
XC9_45 BL45 BLB45 WL9 VDD VSS bitcell_6t
XC9_46 BL46 BLB46 WL9 VDD VSS bitcell_6t
XC9_47 BL47 BLB47 WL9 VDD VSS bitcell_6t
XC9_48 BL48 BLB48 WL9 VDD VSS bitcell_6t
XC9_49 BL49 BLB49 WL9 VDD VSS bitcell_6t
XC9_50 BL50 BLB50 WL9 VDD VSS bitcell_6t
XC9_51 BL51 BLB51 WL9 VDD VSS bitcell_6t
XC9_52 BL52 BLB52 WL9 VDD VSS bitcell_6t
XC9_53 BL53 BLB53 WL9 VDD VSS bitcell_6t
XC9_54 BL54 BLB54 WL9 VDD VSS bitcell_6t
XC9_55 BL55 BLB55 WL9 VDD VSS bitcell_6t
XC9_56 BL56 BLB56 WL9 VDD VSS bitcell_6t
XC9_57 BL57 BLB57 WL9 VDD VSS bitcell_6t
XC9_58 BL58 BLB58 WL9 VDD VSS bitcell_6t
XC9_59 BL59 BLB59 WL9 VDD VSS bitcell_6t
XC9_60 BL60 BLB60 WL9 VDD VSS bitcell_6t
XC9_61 BL61 BLB61 WL9 VDD VSS bitcell_6t
XC9_62 BL62 BLB62 WL9 VDD VSS bitcell_6t
XC9_63 BL63 BLB63 WL9 VDD VSS bitcell_6t
XC9_64 BL64 BLB64 WL9 VDD VSS bitcell_6t
XC9_65 BL65 BLB65 WL9 VDD VSS bitcell_6t
XC9_66 BL66 BLB66 WL9 VDD VSS bitcell_6t
XC9_67 BL67 BLB67 WL9 VDD VSS bitcell_6t
XC9_68 BL68 BLB68 WL9 VDD VSS bitcell_6t
XC9_69 BL69 BLB69 WL9 VDD VSS bitcell_6t
XC9_70 BL70 BLB70 WL9 VDD VSS bitcell_6t
XC9_71 BL71 BLB71 WL9 VDD VSS bitcell_6t
XC9_72 BL72 BLB72 WL9 VDD VSS bitcell_6t
XC9_73 BL73 BLB73 WL9 VDD VSS bitcell_6t
XC9_74 BL74 BLB74 WL9 VDD VSS bitcell_6t
XC9_75 BL75 BLB75 WL9 VDD VSS bitcell_6t
XC9_76 BL76 BLB76 WL9 VDD VSS bitcell_6t
XC9_77 BL77 BLB77 WL9 VDD VSS bitcell_6t
XC9_78 BL78 BLB78 WL9 VDD VSS bitcell_6t
XC9_79 BL79 BLB79 WL9 VDD VSS bitcell_6t
XC9_80 BL80 BLB80 WL9 VDD VSS bitcell_6t
XC9_81 BL81 BLB81 WL9 VDD VSS bitcell_6t
XC9_82 BL82 BLB82 WL9 VDD VSS bitcell_6t
XC9_83 BL83 BLB83 WL9 VDD VSS bitcell_6t
XC9_84 BL84 BLB84 WL9 VDD VSS bitcell_6t
XC9_85 BL85 BLB85 WL9 VDD VSS bitcell_6t
XC9_86 BL86 BLB86 WL9 VDD VSS bitcell_6t
XC9_87 BL87 BLB87 WL9 VDD VSS bitcell_6t
XC9_88 BL88 BLB88 WL9 VDD VSS bitcell_6t
XC9_89 BL89 BLB89 WL9 VDD VSS bitcell_6t
XC9_90 BL90 BLB90 WL9 VDD VSS bitcell_6t
XC9_91 BL91 BLB91 WL9 VDD VSS bitcell_6t
XC9_92 BL92 BLB92 WL9 VDD VSS bitcell_6t
XC9_93 BL93 BLB93 WL9 VDD VSS bitcell_6t
XC9_94 BL94 BLB94 WL9 VDD VSS bitcell_6t
XC9_95 BL95 BLB95 WL9 VDD VSS bitcell_6t
XC9_96 BL96 BLB96 WL9 VDD VSS bitcell_6t
XC9_97 BL97 BLB97 WL9 VDD VSS bitcell_6t
XC9_98 BL98 BLB98 WL9 VDD VSS bitcell_6t
XC9_99 BL99 BLB99 WL9 VDD VSS bitcell_6t
XC9_100 BL100 BLB100 WL9 VDD VSS bitcell_6t
XC9_101 BL101 BLB101 WL9 VDD VSS bitcell_6t
XC9_102 BL102 BLB102 WL9 VDD VSS bitcell_6t
XC9_103 BL103 BLB103 WL9 VDD VSS bitcell_6t
XC9_104 BL104 BLB104 WL9 VDD VSS bitcell_6t
XC9_105 BL105 BLB105 WL9 VDD VSS bitcell_6t
XC9_106 BL106 BLB106 WL9 VDD VSS bitcell_6t
XC9_107 BL107 BLB107 WL9 VDD VSS bitcell_6t
XC9_108 BL108 BLB108 WL9 VDD VSS bitcell_6t
XC9_109 BL109 BLB109 WL9 VDD VSS bitcell_6t
XC9_110 BL110 BLB110 WL9 VDD VSS bitcell_6t
XC9_111 BL111 BLB111 WL9 VDD VSS bitcell_6t
XC9_112 BL112 BLB112 WL9 VDD VSS bitcell_6t
XC9_113 BL113 BLB113 WL9 VDD VSS bitcell_6t
XC9_114 BL114 BLB114 WL9 VDD VSS bitcell_6t
XC9_115 BL115 BLB115 WL9 VDD VSS bitcell_6t
XC9_116 BL116 BLB116 WL9 VDD VSS bitcell_6t
XC9_117 BL117 BLB117 WL9 VDD VSS bitcell_6t
XC9_118 BL118 BLB118 WL9 VDD VSS bitcell_6t
XC9_119 BL119 BLB119 WL9 VDD VSS bitcell_6t
XC9_120 BL120 BLB120 WL9 VDD VSS bitcell_6t
XC9_121 BL121 BLB121 WL9 VDD VSS bitcell_6t
XC9_122 BL122 BLB122 WL9 VDD VSS bitcell_6t
XC9_123 BL123 BLB123 WL9 VDD VSS bitcell_6t
XC9_124 BL124 BLB124 WL9 VDD VSS bitcell_6t
XC9_125 BL125 BLB125 WL9 VDD VSS bitcell_6t
XC9_126 BL126 BLB126 WL9 VDD VSS bitcell_6t
XC9_127 BL127 BLB127 WL9 VDD VSS bitcell_6t
XC10_0 BL0 BLB0 WL10 VDD VSS bitcell_6t
XC10_1 BL1 BLB1 WL10 VDD VSS bitcell_6t
XC10_2 BL2 BLB2 WL10 VDD VSS bitcell_6t
XC10_3 BL3 BLB3 WL10 VDD VSS bitcell_6t
XC10_4 BL4 BLB4 WL10 VDD VSS bitcell_6t
XC10_5 BL5 BLB5 WL10 VDD VSS bitcell_6t
XC10_6 BL6 BLB6 WL10 VDD VSS bitcell_6t
XC10_7 BL7 BLB7 WL10 VDD VSS bitcell_6t
XC10_8 BL8 BLB8 WL10 VDD VSS bitcell_6t
XC10_9 BL9 BLB9 WL10 VDD VSS bitcell_6t
XC10_10 BL10 BLB10 WL10 VDD VSS bitcell_6t
XC10_11 BL11 BLB11 WL10 VDD VSS bitcell_6t
XC10_12 BL12 BLB12 WL10 VDD VSS bitcell_6t
XC10_13 BL13 BLB13 WL10 VDD VSS bitcell_6t
XC10_14 BL14 BLB14 WL10 VDD VSS bitcell_6t
XC10_15 BL15 BLB15 WL10 VDD VSS bitcell_6t
XC10_16 BL16 BLB16 WL10 VDD VSS bitcell_6t
XC10_17 BL17 BLB17 WL10 VDD VSS bitcell_6t
XC10_18 BL18 BLB18 WL10 VDD VSS bitcell_6t
XC10_19 BL19 BLB19 WL10 VDD VSS bitcell_6t
XC10_20 BL20 BLB20 WL10 VDD VSS bitcell_6t
XC10_21 BL21 BLB21 WL10 VDD VSS bitcell_6t
XC10_22 BL22 BLB22 WL10 VDD VSS bitcell_6t
XC10_23 BL23 BLB23 WL10 VDD VSS bitcell_6t
XC10_24 BL24 BLB24 WL10 VDD VSS bitcell_6t
XC10_25 BL25 BLB25 WL10 VDD VSS bitcell_6t
XC10_26 BL26 BLB26 WL10 VDD VSS bitcell_6t
XC10_27 BL27 BLB27 WL10 VDD VSS bitcell_6t
XC10_28 BL28 BLB28 WL10 VDD VSS bitcell_6t
XC10_29 BL29 BLB29 WL10 VDD VSS bitcell_6t
XC10_30 BL30 BLB30 WL10 VDD VSS bitcell_6t
XC10_31 BL31 BLB31 WL10 VDD VSS bitcell_6t
XC10_32 BL32 BLB32 WL10 VDD VSS bitcell_6t
XC10_33 BL33 BLB33 WL10 VDD VSS bitcell_6t
XC10_34 BL34 BLB34 WL10 VDD VSS bitcell_6t
XC10_35 BL35 BLB35 WL10 VDD VSS bitcell_6t
XC10_36 BL36 BLB36 WL10 VDD VSS bitcell_6t
XC10_37 BL37 BLB37 WL10 VDD VSS bitcell_6t
XC10_38 BL38 BLB38 WL10 VDD VSS bitcell_6t
XC10_39 BL39 BLB39 WL10 VDD VSS bitcell_6t
XC10_40 BL40 BLB40 WL10 VDD VSS bitcell_6t
XC10_41 BL41 BLB41 WL10 VDD VSS bitcell_6t
XC10_42 BL42 BLB42 WL10 VDD VSS bitcell_6t
XC10_43 BL43 BLB43 WL10 VDD VSS bitcell_6t
XC10_44 BL44 BLB44 WL10 VDD VSS bitcell_6t
XC10_45 BL45 BLB45 WL10 VDD VSS bitcell_6t
XC10_46 BL46 BLB46 WL10 VDD VSS bitcell_6t
XC10_47 BL47 BLB47 WL10 VDD VSS bitcell_6t
XC10_48 BL48 BLB48 WL10 VDD VSS bitcell_6t
XC10_49 BL49 BLB49 WL10 VDD VSS bitcell_6t
XC10_50 BL50 BLB50 WL10 VDD VSS bitcell_6t
XC10_51 BL51 BLB51 WL10 VDD VSS bitcell_6t
XC10_52 BL52 BLB52 WL10 VDD VSS bitcell_6t
XC10_53 BL53 BLB53 WL10 VDD VSS bitcell_6t
XC10_54 BL54 BLB54 WL10 VDD VSS bitcell_6t
XC10_55 BL55 BLB55 WL10 VDD VSS bitcell_6t
XC10_56 BL56 BLB56 WL10 VDD VSS bitcell_6t
XC10_57 BL57 BLB57 WL10 VDD VSS bitcell_6t
XC10_58 BL58 BLB58 WL10 VDD VSS bitcell_6t
XC10_59 BL59 BLB59 WL10 VDD VSS bitcell_6t
XC10_60 BL60 BLB60 WL10 VDD VSS bitcell_6t
XC10_61 BL61 BLB61 WL10 VDD VSS bitcell_6t
XC10_62 BL62 BLB62 WL10 VDD VSS bitcell_6t
XC10_63 BL63 BLB63 WL10 VDD VSS bitcell_6t
XC10_64 BL64 BLB64 WL10 VDD VSS bitcell_6t
XC10_65 BL65 BLB65 WL10 VDD VSS bitcell_6t
XC10_66 BL66 BLB66 WL10 VDD VSS bitcell_6t
XC10_67 BL67 BLB67 WL10 VDD VSS bitcell_6t
XC10_68 BL68 BLB68 WL10 VDD VSS bitcell_6t
XC10_69 BL69 BLB69 WL10 VDD VSS bitcell_6t
XC10_70 BL70 BLB70 WL10 VDD VSS bitcell_6t
XC10_71 BL71 BLB71 WL10 VDD VSS bitcell_6t
XC10_72 BL72 BLB72 WL10 VDD VSS bitcell_6t
XC10_73 BL73 BLB73 WL10 VDD VSS bitcell_6t
XC10_74 BL74 BLB74 WL10 VDD VSS bitcell_6t
XC10_75 BL75 BLB75 WL10 VDD VSS bitcell_6t
XC10_76 BL76 BLB76 WL10 VDD VSS bitcell_6t
XC10_77 BL77 BLB77 WL10 VDD VSS bitcell_6t
XC10_78 BL78 BLB78 WL10 VDD VSS bitcell_6t
XC10_79 BL79 BLB79 WL10 VDD VSS bitcell_6t
XC10_80 BL80 BLB80 WL10 VDD VSS bitcell_6t
XC10_81 BL81 BLB81 WL10 VDD VSS bitcell_6t
XC10_82 BL82 BLB82 WL10 VDD VSS bitcell_6t
XC10_83 BL83 BLB83 WL10 VDD VSS bitcell_6t
XC10_84 BL84 BLB84 WL10 VDD VSS bitcell_6t
XC10_85 BL85 BLB85 WL10 VDD VSS bitcell_6t
XC10_86 BL86 BLB86 WL10 VDD VSS bitcell_6t
XC10_87 BL87 BLB87 WL10 VDD VSS bitcell_6t
XC10_88 BL88 BLB88 WL10 VDD VSS bitcell_6t
XC10_89 BL89 BLB89 WL10 VDD VSS bitcell_6t
XC10_90 BL90 BLB90 WL10 VDD VSS bitcell_6t
XC10_91 BL91 BLB91 WL10 VDD VSS bitcell_6t
XC10_92 BL92 BLB92 WL10 VDD VSS bitcell_6t
XC10_93 BL93 BLB93 WL10 VDD VSS bitcell_6t
XC10_94 BL94 BLB94 WL10 VDD VSS bitcell_6t
XC10_95 BL95 BLB95 WL10 VDD VSS bitcell_6t
XC10_96 BL96 BLB96 WL10 VDD VSS bitcell_6t
XC10_97 BL97 BLB97 WL10 VDD VSS bitcell_6t
XC10_98 BL98 BLB98 WL10 VDD VSS bitcell_6t
XC10_99 BL99 BLB99 WL10 VDD VSS bitcell_6t
XC10_100 BL100 BLB100 WL10 VDD VSS bitcell_6t
XC10_101 BL101 BLB101 WL10 VDD VSS bitcell_6t
XC10_102 BL102 BLB102 WL10 VDD VSS bitcell_6t
XC10_103 BL103 BLB103 WL10 VDD VSS bitcell_6t
XC10_104 BL104 BLB104 WL10 VDD VSS bitcell_6t
XC10_105 BL105 BLB105 WL10 VDD VSS bitcell_6t
XC10_106 BL106 BLB106 WL10 VDD VSS bitcell_6t
XC10_107 BL107 BLB107 WL10 VDD VSS bitcell_6t
XC10_108 BL108 BLB108 WL10 VDD VSS bitcell_6t
XC10_109 BL109 BLB109 WL10 VDD VSS bitcell_6t
XC10_110 BL110 BLB110 WL10 VDD VSS bitcell_6t
XC10_111 BL111 BLB111 WL10 VDD VSS bitcell_6t
XC10_112 BL112 BLB112 WL10 VDD VSS bitcell_6t
XC10_113 BL113 BLB113 WL10 VDD VSS bitcell_6t
XC10_114 BL114 BLB114 WL10 VDD VSS bitcell_6t
XC10_115 BL115 BLB115 WL10 VDD VSS bitcell_6t
XC10_116 BL116 BLB116 WL10 VDD VSS bitcell_6t
XC10_117 BL117 BLB117 WL10 VDD VSS bitcell_6t
XC10_118 BL118 BLB118 WL10 VDD VSS bitcell_6t
XC10_119 BL119 BLB119 WL10 VDD VSS bitcell_6t
XC10_120 BL120 BLB120 WL10 VDD VSS bitcell_6t
XC10_121 BL121 BLB121 WL10 VDD VSS bitcell_6t
XC10_122 BL122 BLB122 WL10 VDD VSS bitcell_6t
XC10_123 BL123 BLB123 WL10 VDD VSS bitcell_6t
XC10_124 BL124 BLB124 WL10 VDD VSS bitcell_6t
XC10_125 BL125 BLB125 WL10 VDD VSS bitcell_6t
XC10_126 BL126 BLB126 WL10 VDD VSS bitcell_6t
XC10_127 BL127 BLB127 WL10 VDD VSS bitcell_6t
XC11_0 BL0 BLB0 WL11 VDD VSS bitcell_6t
XC11_1 BL1 BLB1 WL11 VDD VSS bitcell_6t
XC11_2 BL2 BLB2 WL11 VDD VSS bitcell_6t
XC11_3 BL3 BLB3 WL11 VDD VSS bitcell_6t
XC11_4 BL4 BLB4 WL11 VDD VSS bitcell_6t
XC11_5 BL5 BLB5 WL11 VDD VSS bitcell_6t
XC11_6 BL6 BLB6 WL11 VDD VSS bitcell_6t
XC11_7 BL7 BLB7 WL11 VDD VSS bitcell_6t
XC11_8 BL8 BLB8 WL11 VDD VSS bitcell_6t
XC11_9 BL9 BLB9 WL11 VDD VSS bitcell_6t
XC11_10 BL10 BLB10 WL11 VDD VSS bitcell_6t
XC11_11 BL11 BLB11 WL11 VDD VSS bitcell_6t
XC11_12 BL12 BLB12 WL11 VDD VSS bitcell_6t
XC11_13 BL13 BLB13 WL11 VDD VSS bitcell_6t
XC11_14 BL14 BLB14 WL11 VDD VSS bitcell_6t
XC11_15 BL15 BLB15 WL11 VDD VSS bitcell_6t
XC11_16 BL16 BLB16 WL11 VDD VSS bitcell_6t
XC11_17 BL17 BLB17 WL11 VDD VSS bitcell_6t
XC11_18 BL18 BLB18 WL11 VDD VSS bitcell_6t
XC11_19 BL19 BLB19 WL11 VDD VSS bitcell_6t
XC11_20 BL20 BLB20 WL11 VDD VSS bitcell_6t
XC11_21 BL21 BLB21 WL11 VDD VSS bitcell_6t
XC11_22 BL22 BLB22 WL11 VDD VSS bitcell_6t
XC11_23 BL23 BLB23 WL11 VDD VSS bitcell_6t
XC11_24 BL24 BLB24 WL11 VDD VSS bitcell_6t
XC11_25 BL25 BLB25 WL11 VDD VSS bitcell_6t
XC11_26 BL26 BLB26 WL11 VDD VSS bitcell_6t
XC11_27 BL27 BLB27 WL11 VDD VSS bitcell_6t
XC11_28 BL28 BLB28 WL11 VDD VSS bitcell_6t
XC11_29 BL29 BLB29 WL11 VDD VSS bitcell_6t
XC11_30 BL30 BLB30 WL11 VDD VSS bitcell_6t
XC11_31 BL31 BLB31 WL11 VDD VSS bitcell_6t
XC11_32 BL32 BLB32 WL11 VDD VSS bitcell_6t
XC11_33 BL33 BLB33 WL11 VDD VSS bitcell_6t
XC11_34 BL34 BLB34 WL11 VDD VSS bitcell_6t
XC11_35 BL35 BLB35 WL11 VDD VSS bitcell_6t
XC11_36 BL36 BLB36 WL11 VDD VSS bitcell_6t
XC11_37 BL37 BLB37 WL11 VDD VSS bitcell_6t
XC11_38 BL38 BLB38 WL11 VDD VSS bitcell_6t
XC11_39 BL39 BLB39 WL11 VDD VSS bitcell_6t
XC11_40 BL40 BLB40 WL11 VDD VSS bitcell_6t
XC11_41 BL41 BLB41 WL11 VDD VSS bitcell_6t
XC11_42 BL42 BLB42 WL11 VDD VSS bitcell_6t
XC11_43 BL43 BLB43 WL11 VDD VSS bitcell_6t
XC11_44 BL44 BLB44 WL11 VDD VSS bitcell_6t
XC11_45 BL45 BLB45 WL11 VDD VSS bitcell_6t
XC11_46 BL46 BLB46 WL11 VDD VSS bitcell_6t
XC11_47 BL47 BLB47 WL11 VDD VSS bitcell_6t
XC11_48 BL48 BLB48 WL11 VDD VSS bitcell_6t
XC11_49 BL49 BLB49 WL11 VDD VSS bitcell_6t
XC11_50 BL50 BLB50 WL11 VDD VSS bitcell_6t
XC11_51 BL51 BLB51 WL11 VDD VSS bitcell_6t
XC11_52 BL52 BLB52 WL11 VDD VSS bitcell_6t
XC11_53 BL53 BLB53 WL11 VDD VSS bitcell_6t
XC11_54 BL54 BLB54 WL11 VDD VSS bitcell_6t
XC11_55 BL55 BLB55 WL11 VDD VSS bitcell_6t
XC11_56 BL56 BLB56 WL11 VDD VSS bitcell_6t
XC11_57 BL57 BLB57 WL11 VDD VSS bitcell_6t
XC11_58 BL58 BLB58 WL11 VDD VSS bitcell_6t
XC11_59 BL59 BLB59 WL11 VDD VSS bitcell_6t
XC11_60 BL60 BLB60 WL11 VDD VSS bitcell_6t
XC11_61 BL61 BLB61 WL11 VDD VSS bitcell_6t
XC11_62 BL62 BLB62 WL11 VDD VSS bitcell_6t
XC11_63 BL63 BLB63 WL11 VDD VSS bitcell_6t
XC11_64 BL64 BLB64 WL11 VDD VSS bitcell_6t
XC11_65 BL65 BLB65 WL11 VDD VSS bitcell_6t
XC11_66 BL66 BLB66 WL11 VDD VSS bitcell_6t
XC11_67 BL67 BLB67 WL11 VDD VSS bitcell_6t
XC11_68 BL68 BLB68 WL11 VDD VSS bitcell_6t
XC11_69 BL69 BLB69 WL11 VDD VSS bitcell_6t
XC11_70 BL70 BLB70 WL11 VDD VSS bitcell_6t
XC11_71 BL71 BLB71 WL11 VDD VSS bitcell_6t
XC11_72 BL72 BLB72 WL11 VDD VSS bitcell_6t
XC11_73 BL73 BLB73 WL11 VDD VSS bitcell_6t
XC11_74 BL74 BLB74 WL11 VDD VSS bitcell_6t
XC11_75 BL75 BLB75 WL11 VDD VSS bitcell_6t
XC11_76 BL76 BLB76 WL11 VDD VSS bitcell_6t
XC11_77 BL77 BLB77 WL11 VDD VSS bitcell_6t
XC11_78 BL78 BLB78 WL11 VDD VSS bitcell_6t
XC11_79 BL79 BLB79 WL11 VDD VSS bitcell_6t
XC11_80 BL80 BLB80 WL11 VDD VSS bitcell_6t
XC11_81 BL81 BLB81 WL11 VDD VSS bitcell_6t
XC11_82 BL82 BLB82 WL11 VDD VSS bitcell_6t
XC11_83 BL83 BLB83 WL11 VDD VSS bitcell_6t
XC11_84 BL84 BLB84 WL11 VDD VSS bitcell_6t
XC11_85 BL85 BLB85 WL11 VDD VSS bitcell_6t
XC11_86 BL86 BLB86 WL11 VDD VSS bitcell_6t
XC11_87 BL87 BLB87 WL11 VDD VSS bitcell_6t
XC11_88 BL88 BLB88 WL11 VDD VSS bitcell_6t
XC11_89 BL89 BLB89 WL11 VDD VSS bitcell_6t
XC11_90 BL90 BLB90 WL11 VDD VSS bitcell_6t
XC11_91 BL91 BLB91 WL11 VDD VSS bitcell_6t
XC11_92 BL92 BLB92 WL11 VDD VSS bitcell_6t
XC11_93 BL93 BLB93 WL11 VDD VSS bitcell_6t
XC11_94 BL94 BLB94 WL11 VDD VSS bitcell_6t
XC11_95 BL95 BLB95 WL11 VDD VSS bitcell_6t
XC11_96 BL96 BLB96 WL11 VDD VSS bitcell_6t
XC11_97 BL97 BLB97 WL11 VDD VSS bitcell_6t
XC11_98 BL98 BLB98 WL11 VDD VSS bitcell_6t
XC11_99 BL99 BLB99 WL11 VDD VSS bitcell_6t
XC11_100 BL100 BLB100 WL11 VDD VSS bitcell_6t
XC11_101 BL101 BLB101 WL11 VDD VSS bitcell_6t
XC11_102 BL102 BLB102 WL11 VDD VSS bitcell_6t
XC11_103 BL103 BLB103 WL11 VDD VSS bitcell_6t
XC11_104 BL104 BLB104 WL11 VDD VSS bitcell_6t
XC11_105 BL105 BLB105 WL11 VDD VSS bitcell_6t
XC11_106 BL106 BLB106 WL11 VDD VSS bitcell_6t
XC11_107 BL107 BLB107 WL11 VDD VSS bitcell_6t
XC11_108 BL108 BLB108 WL11 VDD VSS bitcell_6t
XC11_109 BL109 BLB109 WL11 VDD VSS bitcell_6t
XC11_110 BL110 BLB110 WL11 VDD VSS bitcell_6t
XC11_111 BL111 BLB111 WL11 VDD VSS bitcell_6t
XC11_112 BL112 BLB112 WL11 VDD VSS bitcell_6t
XC11_113 BL113 BLB113 WL11 VDD VSS bitcell_6t
XC11_114 BL114 BLB114 WL11 VDD VSS bitcell_6t
XC11_115 BL115 BLB115 WL11 VDD VSS bitcell_6t
XC11_116 BL116 BLB116 WL11 VDD VSS bitcell_6t
XC11_117 BL117 BLB117 WL11 VDD VSS bitcell_6t
XC11_118 BL118 BLB118 WL11 VDD VSS bitcell_6t
XC11_119 BL119 BLB119 WL11 VDD VSS bitcell_6t
XC11_120 BL120 BLB120 WL11 VDD VSS bitcell_6t
XC11_121 BL121 BLB121 WL11 VDD VSS bitcell_6t
XC11_122 BL122 BLB122 WL11 VDD VSS bitcell_6t
XC11_123 BL123 BLB123 WL11 VDD VSS bitcell_6t
XC11_124 BL124 BLB124 WL11 VDD VSS bitcell_6t
XC11_125 BL125 BLB125 WL11 VDD VSS bitcell_6t
XC11_126 BL126 BLB126 WL11 VDD VSS bitcell_6t
XC11_127 BL127 BLB127 WL11 VDD VSS bitcell_6t
XC12_0 BL0 BLB0 WL12 VDD VSS bitcell_6t
XC12_1 BL1 BLB1 WL12 VDD VSS bitcell_6t
XC12_2 BL2 BLB2 WL12 VDD VSS bitcell_6t
XC12_3 BL3 BLB3 WL12 VDD VSS bitcell_6t
XC12_4 BL4 BLB4 WL12 VDD VSS bitcell_6t
XC12_5 BL5 BLB5 WL12 VDD VSS bitcell_6t
XC12_6 BL6 BLB6 WL12 VDD VSS bitcell_6t
XC12_7 BL7 BLB7 WL12 VDD VSS bitcell_6t
XC12_8 BL8 BLB8 WL12 VDD VSS bitcell_6t
XC12_9 BL9 BLB9 WL12 VDD VSS bitcell_6t
XC12_10 BL10 BLB10 WL12 VDD VSS bitcell_6t
XC12_11 BL11 BLB11 WL12 VDD VSS bitcell_6t
XC12_12 BL12 BLB12 WL12 VDD VSS bitcell_6t
XC12_13 BL13 BLB13 WL12 VDD VSS bitcell_6t
XC12_14 BL14 BLB14 WL12 VDD VSS bitcell_6t
XC12_15 BL15 BLB15 WL12 VDD VSS bitcell_6t
XC12_16 BL16 BLB16 WL12 VDD VSS bitcell_6t
XC12_17 BL17 BLB17 WL12 VDD VSS bitcell_6t
XC12_18 BL18 BLB18 WL12 VDD VSS bitcell_6t
XC12_19 BL19 BLB19 WL12 VDD VSS bitcell_6t
XC12_20 BL20 BLB20 WL12 VDD VSS bitcell_6t
XC12_21 BL21 BLB21 WL12 VDD VSS bitcell_6t
XC12_22 BL22 BLB22 WL12 VDD VSS bitcell_6t
XC12_23 BL23 BLB23 WL12 VDD VSS bitcell_6t
XC12_24 BL24 BLB24 WL12 VDD VSS bitcell_6t
XC12_25 BL25 BLB25 WL12 VDD VSS bitcell_6t
XC12_26 BL26 BLB26 WL12 VDD VSS bitcell_6t
XC12_27 BL27 BLB27 WL12 VDD VSS bitcell_6t
XC12_28 BL28 BLB28 WL12 VDD VSS bitcell_6t
XC12_29 BL29 BLB29 WL12 VDD VSS bitcell_6t
XC12_30 BL30 BLB30 WL12 VDD VSS bitcell_6t
XC12_31 BL31 BLB31 WL12 VDD VSS bitcell_6t
XC12_32 BL32 BLB32 WL12 VDD VSS bitcell_6t
XC12_33 BL33 BLB33 WL12 VDD VSS bitcell_6t
XC12_34 BL34 BLB34 WL12 VDD VSS bitcell_6t
XC12_35 BL35 BLB35 WL12 VDD VSS bitcell_6t
XC12_36 BL36 BLB36 WL12 VDD VSS bitcell_6t
XC12_37 BL37 BLB37 WL12 VDD VSS bitcell_6t
XC12_38 BL38 BLB38 WL12 VDD VSS bitcell_6t
XC12_39 BL39 BLB39 WL12 VDD VSS bitcell_6t
XC12_40 BL40 BLB40 WL12 VDD VSS bitcell_6t
XC12_41 BL41 BLB41 WL12 VDD VSS bitcell_6t
XC12_42 BL42 BLB42 WL12 VDD VSS bitcell_6t
XC12_43 BL43 BLB43 WL12 VDD VSS bitcell_6t
XC12_44 BL44 BLB44 WL12 VDD VSS bitcell_6t
XC12_45 BL45 BLB45 WL12 VDD VSS bitcell_6t
XC12_46 BL46 BLB46 WL12 VDD VSS bitcell_6t
XC12_47 BL47 BLB47 WL12 VDD VSS bitcell_6t
XC12_48 BL48 BLB48 WL12 VDD VSS bitcell_6t
XC12_49 BL49 BLB49 WL12 VDD VSS bitcell_6t
XC12_50 BL50 BLB50 WL12 VDD VSS bitcell_6t
XC12_51 BL51 BLB51 WL12 VDD VSS bitcell_6t
XC12_52 BL52 BLB52 WL12 VDD VSS bitcell_6t
XC12_53 BL53 BLB53 WL12 VDD VSS bitcell_6t
XC12_54 BL54 BLB54 WL12 VDD VSS bitcell_6t
XC12_55 BL55 BLB55 WL12 VDD VSS bitcell_6t
XC12_56 BL56 BLB56 WL12 VDD VSS bitcell_6t
XC12_57 BL57 BLB57 WL12 VDD VSS bitcell_6t
XC12_58 BL58 BLB58 WL12 VDD VSS bitcell_6t
XC12_59 BL59 BLB59 WL12 VDD VSS bitcell_6t
XC12_60 BL60 BLB60 WL12 VDD VSS bitcell_6t
XC12_61 BL61 BLB61 WL12 VDD VSS bitcell_6t
XC12_62 BL62 BLB62 WL12 VDD VSS bitcell_6t
XC12_63 BL63 BLB63 WL12 VDD VSS bitcell_6t
XC12_64 BL64 BLB64 WL12 VDD VSS bitcell_6t
XC12_65 BL65 BLB65 WL12 VDD VSS bitcell_6t
XC12_66 BL66 BLB66 WL12 VDD VSS bitcell_6t
XC12_67 BL67 BLB67 WL12 VDD VSS bitcell_6t
XC12_68 BL68 BLB68 WL12 VDD VSS bitcell_6t
XC12_69 BL69 BLB69 WL12 VDD VSS bitcell_6t
XC12_70 BL70 BLB70 WL12 VDD VSS bitcell_6t
XC12_71 BL71 BLB71 WL12 VDD VSS bitcell_6t
XC12_72 BL72 BLB72 WL12 VDD VSS bitcell_6t
XC12_73 BL73 BLB73 WL12 VDD VSS bitcell_6t
XC12_74 BL74 BLB74 WL12 VDD VSS bitcell_6t
XC12_75 BL75 BLB75 WL12 VDD VSS bitcell_6t
XC12_76 BL76 BLB76 WL12 VDD VSS bitcell_6t
XC12_77 BL77 BLB77 WL12 VDD VSS bitcell_6t
XC12_78 BL78 BLB78 WL12 VDD VSS bitcell_6t
XC12_79 BL79 BLB79 WL12 VDD VSS bitcell_6t
XC12_80 BL80 BLB80 WL12 VDD VSS bitcell_6t
XC12_81 BL81 BLB81 WL12 VDD VSS bitcell_6t
XC12_82 BL82 BLB82 WL12 VDD VSS bitcell_6t
XC12_83 BL83 BLB83 WL12 VDD VSS bitcell_6t
XC12_84 BL84 BLB84 WL12 VDD VSS bitcell_6t
XC12_85 BL85 BLB85 WL12 VDD VSS bitcell_6t
XC12_86 BL86 BLB86 WL12 VDD VSS bitcell_6t
XC12_87 BL87 BLB87 WL12 VDD VSS bitcell_6t
XC12_88 BL88 BLB88 WL12 VDD VSS bitcell_6t
XC12_89 BL89 BLB89 WL12 VDD VSS bitcell_6t
XC12_90 BL90 BLB90 WL12 VDD VSS bitcell_6t
XC12_91 BL91 BLB91 WL12 VDD VSS bitcell_6t
XC12_92 BL92 BLB92 WL12 VDD VSS bitcell_6t
XC12_93 BL93 BLB93 WL12 VDD VSS bitcell_6t
XC12_94 BL94 BLB94 WL12 VDD VSS bitcell_6t
XC12_95 BL95 BLB95 WL12 VDD VSS bitcell_6t
XC12_96 BL96 BLB96 WL12 VDD VSS bitcell_6t
XC12_97 BL97 BLB97 WL12 VDD VSS bitcell_6t
XC12_98 BL98 BLB98 WL12 VDD VSS bitcell_6t
XC12_99 BL99 BLB99 WL12 VDD VSS bitcell_6t
XC12_100 BL100 BLB100 WL12 VDD VSS bitcell_6t
XC12_101 BL101 BLB101 WL12 VDD VSS bitcell_6t
XC12_102 BL102 BLB102 WL12 VDD VSS bitcell_6t
XC12_103 BL103 BLB103 WL12 VDD VSS bitcell_6t
XC12_104 BL104 BLB104 WL12 VDD VSS bitcell_6t
XC12_105 BL105 BLB105 WL12 VDD VSS bitcell_6t
XC12_106 BL106 BLB106 WL12 VDD VSS bitcell_6t
XC12_107 BL107 BLB107 WL12 VDD VSS bitcell_6t
XC12_108 BL108 BLB108 WL12 VDD VSS bitcell_6t
XC12_109 BL109 BLB109 WL12 VDD VSS bitcell_6t
XC12_110 BL110 BLB110 WL12 VDD VSS bitcell_6t
XC12_111 BL111 BLB111 WL12 VDD VSS bitcell_6t
XC12_112 BL112 BLB112 WL12 VDD VSS bitcell_6t
XC12_113 BL113 BLB113 WL12 VDD VSS bitcell_6t
XC12_114 BL114 BLB114 WL12 VDD VSS bitcell_6t
XC12_115 BL115 BLB115 WL12 VDD VSS bitcell_6t
XC12_116 BL116 BLB116 WL12 VDD VSS bitcell_6t
XC12_117 BL117 BLB117 WL12 VDD VSS bitcell_6t
XC12_118 BL118 BLB118 WL12 VDD VSS bitcell_6t
XC12_119 BL119 BLB119 WL12 VDD VSS bitcell_6t
XC12_120 BL120 BLB120 WL12 VDD VSS bitcell_6t
XC12_121 BL121 BLB121 WL12 VDD VSS bitcell_6t
XC12_122 BL122 BLB122 WL12 VDD VSS bitcell_6t
XC12_123 BL123 BLB123 WL12 VDD VSS bitcell_6t
XC12_124 BL124 BLB124 WL12 VDD VSS bitcell_6t
XC12_125 BL125 BLB125 WL12 VDD VSS bitcell_6t
XC12_126 BL126 BLB126 WL12 VDD VSS bitcell_6t
XC12_127 BL127 BLB127 WL12 VDD VSS bitcell_6t
XC13_0 BL0 BLB0 WL13 VDD VSS bitcell_6t
XC13_1 BL1 BLB1 WL13 VDD VSS bitcell_6t
XC13_2 BL2 BLB2 WL13 VDD VSS bitcell_6t
XC13_3 BL3 BLB3 WL13 VDD VSS bitcell_6t
XC13_4 BL4 BLB4 WL13 VDD VSS bitcell_6t
XC13_5 BL5 BLB5 WL13 VDD VSS bitcell_6t
XC13_6 BL6 BLB6 WL13 VDD VSS bitcell_6t
XC13_7 BL7 BLB7 WL13 VDD VSS bitcell_6t
XC13_8 BL8 BLB8 WL13 VDD VSS bitcell_6t
XC13_9 BL9 BLB9 WL13 VDD VSS bitcell_6t
XC13_10 BL10 BLB10 WL13 VDD VSS bitcell_6t
XC13_11 BL11 BLB11 WL13 VDD VSS bitcell_6t
XC13_12 BL12 BLB12 WL13 VDD VSS bitcell_6t
XC13_13 BL13 BLB13 WL13 VDD VSS bitcell_6t
XC13_14 BL14 BLB14 WL13 VDD VSS bitcell_6t
XC13_15 BL15 BLB15 WL13 VDD VSS bitcell_6t
XC13_16 BL16 BLB16 WL13 VDD VSS bitcell_6t
XC13_17 BL17 BLB17 WL13 VDD VSS bitcell_6t
XC13_18 BL18 BLB18 WL13 VDD VSS bitcell_6t
XC13_19 BL19 BLB19 WL13 VDD VSS bitcell_6t
XC13_20 BL20 BLB20 WL13 VDD VSS bitcell_6t
XC13_21 BL21 BLB21 WL13 VDD VSS bitcell_6t
XC13_22 BL22 BLB22 WL13 VDD VSS bitcell_6t
XC13_23 BL23 BLB23 WL13 VDD VSS bitcell_6t
XC13_24 BL24 BLB24 WL13 VDD VSS bitcell_6t
XC13_25 BL25 BLB25 WL13 VDD VSS bitcell_6t
XC13_26 BL26 BLB26 WL13 VDD VSS bitcell_6t
XC13_27 BL27 BLB27 WL13 VDD VSS bitcell_6t
XC13_28 BL28 BLB28 WL13 VDD VSS bitcell_6t
XC13_29 BL29 BLB29 WL13 VDD VSS bitcell_6t
XC13_30 BL30 BLB30 WL13 VDD VSS bitcell_6t
XC13_31 BL31 BLB31 WL13 VDD VSS bitcell_6t
XC13_32 BL32 BLB32 WL13 VDD VSS bitcell_6t
XC13_33 BL33 BLB33 WL13 VDD VSS bitcell_6t
XC13_34 BL34 BLB34 WL13 VDD VSS bitcell_6t
XC13_35 BL35 BLB35 WL13 VDD VSS bitcell_6t
XC13_36 BL36 BLB36 WL13 VDD VSS bitcell_6t
XC13_37 BL37 BLB37 WL13 VDD VSS bitcell_6t
XC13_38 BL38 BLB38 WL13 VDD VSS bitcell_6t
XC13_39 BL39 BLB39 WL13 VDD VSS bitcell_6t
XC13_40 BL40 BLB40 WL13 VDD VSS bitcell_6t
XC13_41 BL41 BLB41 WL13 VDD VSS bitcell_6t
XC13_42 BL42 BLB42 WL13 VDD VSS bitcell_6t
XC13_43 BL43 BLB43 WL13 VDD VSS bitcell_6t
XC13_44 BL44 BLB44 WL13 VDD VSS bitcell_6t
XC13_45 BL45 BLB45 WL13 VDD VSS bitcell_6t
XC13_46 BL46 BLB46 WL13 VDD VSS bitcell_6t
XC13_47 BL47 BLB47 WL13 VDD VSS bitcell_6t
XC13_48 BL48 BLB48 WL13 VDD VSS bitcell_6t
XC13_49 BL49 BLB49 WL13 VDD VSS bitcell_6t
XC13_50 BL50 BLB50 WL13 VDD VSS bitcell_6t
XC13_51 BL51 BLB51 WL13 VDD VSS bitcell_6t
XC13_52 BL52 BLB52 WL13 VDD VSS bitcell_6t
XC13_53 BL53 BLB53 WL13 VDD VSS bitcell_6t
XC13_54 BL54 BLB54 WL13 VDD VSS bitcell_6t
XC13_55 BL55 BLB55 WL13 VDD VSS bitcell_6t
XC13_56 BL56 BLB56 WL13 VDD VSS bitcell_6t
XC13_57 BL57 BLB57 WL13 VDD VSS bitcell_6t
XC13_58 BL58 BLB58 WL13 VDD VSS bitcell_6t
XC13_59 BL59 BLB59 WL13 VDD VSS bitcell_6t
XC13_60 BL60 BLB60 WL13 VDD VSS bitcell_6t
XC13_61 BL61 BLB61 WL13 VDD VSS bitcell_6t
XC13_62 BL62 BLB62 WL13 VDD VSS bitcell_6t
XC13_63 BL63 BLB63 WL13 VDD VSS bitcell_6t
XC13_64 BL64 BLB64 WL13 VDD VSS bitcell_6t
XC13_65 BL65 BLB65 WL13 VDD VSS bitcell_6t
XC13_66 BL66 BLB66 WL13 VDD VSS bitcell_6t
XC13_67 BL67 BLB67 WL13 VDD VSS bitcell_6t
XC13_68 BL68 BLB68 WL13 VDD VSS bitcell_6t
XC13_69 BL69 BLB69 WL13 VDD VSS bitcell_6t
XC13_70 BL70 BLB70 WL13 VDD VSS bitcell_6t
XC13_71 BL71 BLB71 WL13 VDD VSS bitcell_6t
XC13_72 BL72 BLB72 WL13 VDD VSS bitcell_6t
XC13_73 BL73 BLB73 WL13 VDD VSS bitcell_6t
XC13_74 BL74 BLB74 WL13 VDD VSS bitcell_6t
XC13_75 BL75 BLB75 WL13 VDD VSS bitcell_6t
XC13_76 BL76 BLB76 WL13 VDD VSS bitcell_6t
XC13_77 BL77 BLB77 WL13 VDD VSS bitcell_6t
XC13_78 BL78 BLB78 WL13 VDD VSS bitcell_6t
XC13_79 BL79 BLB79 WL13 VDD VSS bitcell_6t
XC13_80 BL80 BLB80 WL13 VDD VSS bitcell_6t
XC13_81 BL81 BLB81 WL13 VDD VSS bitcell_6t
XC13_82 BL82 BLB82 WL13 VDD VSS bitcell_6t
XC13_83 BL83 BLB83 WL13 VDD VSS bitcell_6t
XC13_84 BL84 BLB84 WL13 VDD VSS bitcell_6t
XC13_85 BL85 BLB85 WL13 VDD VSS bitcell_6t
XC13_86 BL86 BLB86 WL13 VDD VSS bitcell_6t
XC13_87 BL87 BLB87 WL13 VDD VSS bitcell_6t
XC13_88 BL88 BLB88 WL13 VDD VSS bitcell_6t
XC13_89 BL89 BLB89 WL13 VDD VSS bitcell_6t
XC13_90 BL90 BLB90 WL13 VDD VSS bitcell_6t
XC13_91 BL91 BLB91 WL13 VDD VSS bitcell_6t
XC13_92 BL92 BLB92 WL13 VDD VSS bitcell_6t
XC13_93 BL93 BLB93 WL13 VDD VSS bitcell_6t
XC13_94 BL94 BLB94 WL13 VDD VSS bitcell_6t
XC13_95 BL95 BLB95 WL13 VDD VSS bitcell_6t
XC13_96 BL96 BLB96 WL13 VDD VSS bitcell_6t
XC13_97 BL97 BLB97 WL13 VDD VSS bitcell_6t
XC13_98 BL98 BLB98 WL13 VDD VSS bitcell_6t
XC13_99 BL99 BLB99 WL13 VDD VSS bitcell_6t
XC13_100 BL100 BLB100 WL13 VDD VSS bitcell_6t
XC13_101 BL101 BLB101 WL13 VDD VSS bitcell_6t
XC13_102 BL102 BLB102 WL13 VDD VSS bitcell_6t
XC13_103 BL103 BLB103 WL13 VDD VSS bitcell_6t
XC13_104 BL104 BLB104 WL13 VDD VSS bitcell_6t
XC13_105 BL105 BLB105 WL13 VDD VSS bitcell_6t
XC13_106 BL106 BLB106 WL13 VDD VSS bitcell_6t
XC13_107 BL107 BLB107 WL13 VDD VSS bitcell_6t
XC13_108 BL108 BLB108 WL13 VDD VSS bitcell_6t
XC13_109 BL109 BLB109 WL13 VDD VSS bitcell_6t
XC13_110 BL110 BLB110 WL13 VDD VSS bitcell_6t
XC13_111 BL111 BLB111 WL13 VDD VSS bitcell_6t
XC13_112 BL112 BLB112 WL13 VDD VSS bitcell_6t
XC13_113 BL113 BLB113 WL13 VDD VSS bitcell_6t
XC13_114 BL114 BLB114 WL13 VDD VSS bitcell_6t
XC13_115 BL115 BLB115 WL13 VDD VSS bitcell_6t
XC13_116 BL116 BLB116 WL13 VDD VSS bitcell_6t
XC13_117 BL117 BLB117 WL13 VDD VSS bitcell_6t
XC13_118 BL118 BLB118 WL13 VDD VSS bitcell_6t
XC13_119 BL119 BLB119 WL13 VDD VSS bitcell_6t
XC13_120 BL120 BLB120 WL13 VDD VSS bitcell_6t
XC13_121 BL121 BLB121 WL13 VDD VSS bitcell_6t
XC13_122 BL122 BLB122 WL13 VDD VSS bitcell_6t
XC13_123 BL123 BLB123 WL13 VDD VSS bitcell_6t
XC13_124 BL124 BLB124 WL13 VDD VSS bitcell_6t
XC13_125 BL125 BLB125 WL13 VDD VSS bitcell_6t
XC13_126 BL126 BLB126 WL13 VDD VSS bitcell_6t
XC13_127 BL127 BLB127 WL13 VDD VSS bitcell_6t
XC14_0 BL0 BLB0 WL14 VDD VSS bitcell_6t
XC14_1 BL1 BLB1 WL14 VDD VSS bitcell_6t
XC14_2 BL2 BLB2 WL14 VDD VSS bitcell_6t
XC14_3 BL3 BLB3 WL14 VDD VSS bitcell_6t
XC14_4 BL4 BLB4 WL14 VDD VSS bitcell_6t
XC14_5 BL5 BLB5 WL14 VDD VSS bitcell_6t
XC14_6 BL6 BLB6 WL14 VDD VSS bitcell_6t
XC14_7 BL7 BLB7 WL14 VDD VSS bitcell_6t
XC14_8 BL8 BLB8 WL14 VDD VSS bitcell_6t
XC14_9 BL9 BLB9 WL14 VDD VSS bitcell_6t
XC14_10 BL10 BLB10 WL14 VDD VSS bitcell_6t
XC14_11 BL11 BLB11 WL14 VDD VSS bitcell_6t
XC14_12 BL12 BLB12 WL14 VDD VSS bitcell_6t
XC14_13 BL13 BLB13 WL14 VDD VSS bitcell_6t
XC14_14 BL14 BLB14 WL14 VDD VSS bitcell_6t
XC14_15 BL15 BLB15 WL14 VDD VSS bitcell_6t
XC14_16 BL16 BLB16 WL14 VDD VSS bitcell_6t
XC14_17 BL17 BLB17 WL14 VDD VSS bitcell_6t
XC14_18 BL18 BLB18 WL14 VDD VSS bitcell_6t
XC14_19 BL19 BLB19 WL14 VDD VSS bitcell_6t
XC14_20 BL20 BLB20 WL14 VDD VSS bitcell_6t
XC14_21 BL21 BLB21 WL14 VDD VSS bitcell_6t
XC14_22 BL22 BLB22 WL14 VDD VSS bitcell_6t
XC14_23 BL23 BLB23 WL14 VDD VSS bitcell_6t
XC14_24 BL24 BLB24 WL14 VDD VSS bitcell_6t
XC14_25 BL25 BLB25 WL14 VDD VSS bitcell_6t
XC14_26 BL26 BLB26 WL14 VDD VSS bitcell_6t
XC14_27 BL27 BLB27 WL14 VDD VSS bitcell_6t
XC14_28 BL28 BLB28 WL14 VDD VSS bitcell_6t
XC14_29 BL29 BLB29 WL14 VDD VSS bitcell_6t
XC14_30 BL30 BLB30 WL14 VDD VSS bitcell_6t
XC14_31 BL31 BLB31 WL14 VDD VSS bitcell_6t
XC14_32 BL32 BLB32 WL14 VDD VSS bitcell_6t
XC14_33 BL33 BLB33 WL14 VDD VSS bitcell_6t
XC14_34 BL34 BLB34 WL14 VDD VSS bitcell_6t
XC14_35 BL35 BLB35 WL14 VDD VSS bitcell_6t
XC14_36 BL36 BLB36 WL14 VDD VSS bitcell_6t
XC14_37 BL37 BLB37 WL14 VDD VSS bitcell_6t
XC14_38 BL38 BLB38 WL14 VDD VSS bitcell_6t
XC14_39 BL39 BLB39 WL14 VDD VSS bitcell_6t
XC14_40 BL40 BLB40 WL14 VDD VSS bitcell_6t
XC14_41 BL41 BLB41 WL14 VDD VSS bitcell_6t
XC14_42 BL42 BLB42 WL14 VDD VSS bitcell_6t
XC14_43 BL43 BLB43 WL14 VDD VSS bitcell_6t
XC14_44 BL44 BLB44 WL14 VDD VSS bitcell_6t
XC14_45 BL45 BLB45 WL14 VDD VSS bitcell_6t
XC14_46 BL46 BLB46 WL14 VDD VSS bitcell_6t
XC14_47 BL47 BLB47 WL14 VDD VSS bitcell_6t
XC14_48 BL48 BLB48 WL14 VDD VSS bitcell_6t
XC14_49 BL49 BLB49 WL14 VDD VSS bitcell_6t
XC14_50 BL50 BLB50 WL14 VDD VSS bitcell_6t
XC14_51 BL51 BLB51 WL14 VDD VSS bitcell_6t
XC14_52 BL52 BLB52 WL14 VDD VSS bitcell_6t
XC14_53 BL53 BLB53 WL14 VDD VSS bitcell_6t
XC14_54 BL54 BLB54 WL14 VDD VSS bitcell_6t
XC14_55 BL55 BLB55 WL14 VDD VSS bitcell_6t
XC14_56 BL56 BLB56 WL14 VDD VSS bitcell_6t
XC14_57 BL57 BLB57 WL14 VDD VSS bitcell_6t
XC14_58 BL58 BLB58 WL14 VDD VSS bitcell_6t
XC14_59 BL59 BLB59 WL14 VDD VSS bitcell_6t
XC14_60 BL60 BLB60 WL14 VDD VSS bitcell_6t
XC14_61 BL61 BLB61 WL14 VDD VSS bitcell_6t
XC14_62 BL62 BLB62 WL14 VDD VSS bitcell_6t
XC14_63 BL63 BLB63 WL14 VDD VSS bitcell_6t
XC14_64 BL64 BLB64 WL14 VDD VSS bitcell_6t
XC14_65 BL65 BLB65 WL14 VDD VSS bitcell_6t
XC14_66 BL66 BLB66 WL14 VDD VSS bitcell_6t
XC14_67 BL67 BLB67 WL14 VDD VSS bitcell_6t
XC14_68 BL68 BLB68 WL14 VDD VSS bitcell_6t
XC14_69 BL69 BLB69 WL14 VDD VSS bitcell_6t
XC14_70 BL70 BLB70 WL14 VDD VSS bitcell_6t
XC14_71 BL71 BLB71 WL14 VDD VSS bitcell_6t
XC14_72 BL72 BLB72 WL14 VDD VSS bitcell_6t
XC14_73 BL73 BLB73 WL14 VDD VSS bitcell_6t
XC14_74 BL74 BLB74 WL14 VDD VSS bitcell_6t
XC14_75 BL75 BLB75 WL14 VDD VSS bitcell_6t
XC14_76 BL76 BLB76 WL14 VDD VSS bitcell_6t
XC14_77 BL77 BLB77 WL14 VDD VSS bitcell_6t
XC14_78 BL78 BLB78 WL14 VDD VSS bitcell_6t
XC14_79 BL79 BLB79 WL14 VDD VSS bitcell_6t
XC14_80 BL80 BLB80 WL14 VDD VSS bitcell_6t
XC14_81 BL81 BLB81 WL14 VDD VSS bitcell_6t
XC14_82 BL82 BLB82 WL14 VDD VSS bitcell_6t
XC14_83 BL83 BLB83 WL14 VDD VSS bitcell_6t
XC14_84 BL84 BLB84 WL14 VDD VSS bitcell_6t
XC14_85 BL85 BLB85 WL14 VDD VSS bitcell_6t
XC14_86 BL86 BLB86 WL14 VDD VSS bitcell_6t
XC14_87 BL87 BLB87 WL14 VDD VSS bitcell_6t
XC14_88 BL88 BLB88 WL14 VDD VSS bitcell_6t
XC14_89 BL89 BLB89 WL14 VDD VSS bitcell_6t
XC14_90 BL90 BLB90 WL14 VDD VSS bitcell_6t
XC14_91 BL91 BLB91 WL14 VDD VSS bitcell_6t
XC14_92 BL92 BLB92 WL14 VDD VSS bitcell_6t
XC14_93 BL93 BLB93 WL14 VDD VSS bitcell_6t
XC14_94 BL94 BLB94 WL14 VDD VSS bitcell_6t
XC14_95 BL95 BLB95 WL14 VDD VSS bitcell_6t
XC14_96 BL96 BLB96 WL14 VDD VSS bitcell_6t
XC14_97 BL97 BLB97 WL14 VDD VSS bitcell_6t
XC14_98 BL98 BLB98 WL14 VDD VSS bitcell_6t
XC14_99 BL99 BLB99 WL14 VDD VSS bitcell_6t
XC14_100 BL100 BLB100 WL14 VDD VSS bitcell_6t
XC14_101 BL101 BLB101 WL14 VDD VSS bitcell_6t
XC14_102 BL102 BLB102 WL14 VDD VSS bitcell_6t
XC14_103 BL103 BLB103 WL14 VDD VSS bitcell_6t
XC14_104 BL104 BLB104 WL14 VDD VSS bitcell_6t
XC14_105 BL105 BLB105 WL14 VDD VSS bitcell_6t
XC14_106 BL106 BLB106 WL14 VDD VSS bitcell_6t
XC14_107 BL107 BLB107 WL14 VDD VSS bitcell_6t
XC14_108 BL108 BLB108 WL14 VDD VSS bitcell_6t
XC14_109 BL109 BLB109 WL14 VDD VSS bitcell_6t
XC14_110 BL110 BLB110 WL14 VDD VSS bitcell_6t
XC14_111 BL111 BLB111 WL14 VDD VSS bitcell_6t
XC14_112 BL112 BLB112 WL14 VDD VSS bitcell_6t
XC14_113 BL113 BLB113 WL14 VDD VSS bitcell_6t
XC14_114 BL114 BLB114 WL14 VDD VSS bitcell_6t
XC14_115 BL115 BLB115 WL14 VDD VSS bitcell_6t
XC14_116 BL116 BLB116 WL14 VDD VSS bitcell_6t
XC14_117 BL117 BLB117 WL14 VDD VSS bitcell_6t
XC14_118 BL118 BLB118 WL14 VDD VSS bitcell_6t
XC14_119 BL119 BLB119 WL14 VDD VSS bitcell_6t
XC14_120 BL120 BLB120 WL14 VDD VSS bitcell_6t
XC14_121 BL121 BLB121 WL14 VDD VSS bitcell_6t
XC14_122 BL122 BLB122 WL14 VDD VSS bitcell_6t
XC14_123 BL123 BLB123 WL14 VDD VSS bitcell_6t
XC14_124 BL124 BLB124 WL14 VDD VSS bitcell_6t
XC14_125 BL125 BLB125 WL14 VDD VSS bitcell_6t
XC14_126 BL126 BLB126 WL14 VDD VSS bitcell_6t
XC14_127 BL127 BLB127 WL14 VDD VSS bitcell_6t
XC15_0 BL0 BLB0 WL15 VDD VSS bitcell_6t
XC15_1 BL1 BLB1 WL15 VDD VSS bitcell_6t
XC15_2 BL2 BLB2 WL15 VDD VSS bitcell_6t
XC15_3 BL3 BLB3 WL15 VDD VSS bitcell_6t
XC15_4 BL4 BLB4 WL15 VDD VSS bitcell_6t
XC15_5 BL5 BLB5 WL15 VDD VSS bitcell_6t
XC15_6 BL6 BLB6 WL15 VDD VSS bitcell_6t
XC15_7 BL7 BLB7 WL15 VDD VSS bitcell_6t
XC15_8 BL8 BLB8 WL15 VDD VSS bitcell_6t
XC15_9 BL9 BLB9 WL15 VDD VSS bitcell_6t
XC15_10 BL10 BLB10 WL15 VDD VSS bitcell_6t
XC15_11 BL11 BLB11 WL15 VDD VSS bitcell_6t
XC15_12 BL12 BLB12 WL15 VDD VSS bitcell_6t
XC15_13 BL13 BLB13 WL15 VDD VSS bitcell_6t
XC15_14 BL14 BLB14 WL15 VDD VSS bitcell_6t
XC15_15 BL15 BLB15 WL15 VDD VSS bitcell_6t
XC15_16 BL16 BLB16 WL15 VDD VSS bitcell_6t
XC15_17 BL17 BLB17 WL15 VDD VSS bitcell_6t
XC15_18 BL18 BLB18 WL15 VDD VSS bitcell_6t
XC15_19 BL19 BLB19 WL15 VDD VSS bitcell_6t
XC15_20 BL20 BLB20 WL15 VDD VSS bitcell_6t
XC15_21 BL21 BLB21 WL15 VDD VSS bitcell_6t
XC15_22 BL22 BLB22 WL15 VDD VSS bitcell_6t
XC15_23 BL23 BLB23 WL15 VDD VSS bitcell_6t
XC15_24 BL24 BLB24 WL15 VDD VSS bitcell_6t
XC15_25 BL25 BLB25 WL15 VDD VSS bitcell_6t
XC15_26 BL26 BLB26 WL15 VDD VSS bitcell_6t
XC15_27 BL27 BLB27 WL15 VDD VSS bitcell_6t
XC15_28 BL28 BLB28 WL15 VDD VSS bitcell_6t
XC15_29 BL29 BLB29 WL15 VDD VSS bitcell_6t
XC15_30 BL30 BLB30 WL15 VDD VSS bitcell_6t
XC15_31 BL31 BLB31 WL15 VDD VSS bitcell_6t
XC15_32 BL32 BLB32 WL15 VDD VSS bitcell_6t
XC15_33 BL33 BLB33 WL15 VDD VSS bitcell_6t
XC15_34 BL34 BLB34 WL15 VDD VSS bitcell_6t
XC15_35 BL35 BLB35 WL15 VDD VSS bitcell_6t
XC15_36 BL36 BLB36 WL15 VDD VSS bitcell_6t
XC15_37 BL37 BLB37 WL15 VDD VSS bitcell_6t
XC15_38 BL38 BLB38 WL15 VDD VSS bitcell_6t
XC15_39 BL39 BLB39 WL15 VDD VSS bitcell_6t
XC15_40 BL40 BLB40 WL15 VDD VSS bitcell_6t
XC15_41 BL41 BLB41 WL15 VDD VSS bitcell_6t
XC15_42 BL42 BLB42 WL15 VDD VSS bitcell_6t
XC15_43 BL43 BLB43 WL15 VDD VSS bitcell_6t
XC15_44 BL44 BLB44 WL15 VDD VSS bitcell_6t
XC15_45 BL45 BLB45 WL15 VDD VSS bitcell_6t
XC15_46 BL46 BLB46 WL15 VDD VSS bitcell_6t
XC15_47 BL47 BLB47 WL15 VDD VSS bitcell_6t
XC15_48 BL48 BLB48 WL15 VDD VSS bitcell_6t
XC15_49 BL49 BLB49 WL15 VDD VSS bitcell_6t
XC15_50 BL50 BLB50 WL15 VDD VSS bitcell_6t
XC15_51 BL51 BLB51 WL15 VDD VSS bitcell_6t
XC15_52 BL52 BLB52 WL15 VDD VSS bitcell_6t
XC15_53 BL53 BLB53 WL15 VDD VSS bitcell_6t
XC15_54 BL54 BLB54 WL15 VDD VSS bitcell_6t
XC15_55 BL55 BLB55 WL15 VDD VSS bitcell_6t
XC15_56 BL56 BLB56 WL15 VDD VSS bitcell_6t
XC15_57 BL57 BLB57 WL15 VDD VSS bitcell_6t
XC15_58 BL58 BLB58 WL15 VDD VSS bitcell_6t
XC15_59 BL59 BLB59 WL15 VDD VSS bitcell_6t
XC15_60 BL60 BLB60 WL15 VDD VSS bitcell_6t
XC15_61 BL61 BLB61 WL15 VDD VSS bitcell_6t
XC15_62 BL62 BLB62 WL15 VDD VSS bitcell_6t
XC15_63 BL63 BLB63 WL15 VDD VSS bitcell_6t
XC15_64 BL64 BLB64 WL15 VDD VSS bitcell_6t
XC15_65 BL65 BLB65 WL15 VDD VSS bitcell_6t
XC15_66 BL66 BLB66 WL15 VDD VSS bitcell_6t
XC15_67 BL67 BLB67 WL15 VDD VSS bitcell_6t
XC15_68 BL68 BLB68 WL15 VDD VSS bitcell_6t
XC15_69 BL69 BLB69 WL15 VDD VSS bitcell_6t
XC15_70 BL70 BLB70 WL15 VDD VSS bitcell_6t
XC15_71 BL71 BLB71 WL15 VDD VSS bitcell_6t
XC15_72 BL72 BLB72 WL15 VDD VSS bitcell_6t
XC15_73 BL73 BLB73 WL15 VDD VSS bitcell_6t
XC15_74 BL74 BLB74 WL15 VDD VSS bitcell_6t
XC15_75 BL75 BLB75 WL15 VDD VSS bitcell_6t
XC15_76 BL76 BLB76 WL15 VDD VSS bitcell_6t
XC15_77 BL77 BLB77 WL15 VDD VSS bitcell_6t
XC15_78 BL78 BLB78 WL15 VDD VSS bitcell_6t
XC15_79 BL79 BLB79 WL15 VDD VSS bitcell_6t
XC15_80 BL80 BLB80 WL15 VDD VSS bitcell_6t
XC15_81 BL81 BLB81 WL15 VDD VSS bitcell_6t
XC15_82 BL82 BLB82 WL15 VDD VSS bitcell_6t
XC15_83 BL83 BLB83 WL15 VDD VSS bitcell_6t
XC15_84 BL84 BLB84 WL15 VDD VSS bitcell_6t
XC15_85 BL85 BLB85 WL15 VDD VSS bitcell_6t
XC15_86 BL86 BLB86 WL15 VDD VSS bitcell_6t
XC15_87 BL87 BLB87 WL15 VDD VSS bitcell_6t
XC15_88 BL88 BLB88 WL15 VDD VSS bitcell_6t
XC15_89 BL89 BLB89 WL15 VDD VSS bitcell_6t
XC15_90 BL90 BLB90 WL15 VDD VSS bitcell_6t
XC15_91 BL91 BLB91 WL15 VDD VSS bitcell_6t
XC15_92 BL92 BLB92 WL15 VDD VSS bitcell_6t
XC15_93 BL93 BLB93 WL15 VDD VSS bitcell_6t
XC15_94 BL94 BLB94 WL15 VDD VSS bitcell_6t
XC15_95 BL95 BLB95 WL15 VDD VSS bitcell_6t
XC15_96 BL96 BLB96 WL15 VDD VSS bitcell_6t
XC15_97 BL97 BLB97 WL15 VDD VSS bitcell_6t
XC15_98 BL98 BLB98 WL15 VDD VSS bitcell_6t
XC15_99 BL99 BLB99 WL15 VDD VSS bitcell_6t
XC15_100 BL100 BLB100 WL15 VDD VSS bitcell_6t
XC15_101 BL101 BLB101 WL15 VDD VSS bitcell_6t
XC15_102 BL102 BLB102 WL15 VDD VSS bitcell_6t
XC15_103 BL103 BLB103 WL15 VDD VSS bitcell_6t
XC15_104 BL104 BLB104 WL15 VDD VSS bitcell_6t
XC15_105 BL105 BLB105 WL15 VDD VSS bitcell_6t
XC15_106 BL106 BLB106 WL15 VDD VSS bitcell_6t
XC15_107 BL107 BLB107 WL15 VDD VSS bitcell_6t
XC15_108 BL108 BLB108 WL15 VDD VSS bitcell_6t
XC15_109 BL109 BLB109 WL15 VDD VSS bitcell_6t
XC15_110 BL110 BLB110 WL15 VDD VSS bitcell_6t
XC15_111 BL111 BLB111 WL15 VDD VSS bitcell_6t
XC15_112 BL112 BLB112 WL15 VDD VSS bitcell_6t
XC15_113 BL113 BLB113 WL15 VDD VSS bitcell_6t
XC15_114 BL114 BLB114 WL15 VDD VSS bitcell_6t
XC15_115 BL115 BLB115 WL15 VDD VSS bitcell_6t
XC15_116 BL116 BLB116 WL15 VDD VSS bitcell_6t
XC15_117 BL117 BLB117 WL15 VDD VSS bitcell_6t
XC15_118 BL118 BLB118 WL15 VDD VSS bitcell_6t
XC15_119 BL119 BLB119 WL15 VDD VSS bitcell_6t
XC15_120 BL120 BLB120 WL15 VDD VSS bitcell_6t
XC15_121 BL121 BLB121 WL15 VDD VSS bitcell_6t
XC15_122 BL122 BLB122 WL15 VDD VSS bitcell_6t
XC15_123 BL123 BLB123 WL15 VDD VSS bitcell_6t
XC15_124 BL124 BLB124 WL15 VDD VSS bitcell_6t
XC15_125 BL125 BLB125 WL15 VDD VSS bitcell_6t
XC15_126 BL126 BLB126 WL15 VDD VSS bitcell_6t
XC15_127 BL127 BLB127 WL15 VDD VSS bitcell_6t
XC16_0 BL0 BLB0 WL16 VDD VSS bitcell_6t
XC16_1 BL1 BLB1 WL16 VDD VSS bitcell_6t
XC16_2 BL2 BLB2 WL16 VDD VSS bitcell_6t
XC16_3 BL3 BLB3 WL16 VDD VSS bitcell_6t
XC16_4 BL4 BLB4 WL16 VDD VSS bitcell_6t
XC16_5 BL5 BLB5 WL16 VDD VSS bitcell_6t
XC16_6 BL6 BLB6 WL16 VDD VSS bitcell_6t
XC16_7 BL7 BLB7 WL16 VDD VSS bitcell_6t
XC16_8 BL8 BLB8 WL16 VDD VSS bitcell_6t
XC16_9 BL9 BLB9 WL16 VDD VSS bitcell_6t
XC16_10 BL10 BLB10 WL16 VDD VSS bitcell_6t
XC16_11 BL11 BLB11 WL16 VDD VSS bitcell_6t
XC16_12 BL12 BLB12 WL16 VDD VSS bitcell_6t
XC16_13 BL13 BLB13 WL16 VDD VSS bitcell_6t
XC16_14 BL14 BLB14 WL16 VDD VSS bitcell_6t
XC16_15 BL15 BLB15 WL16 VDD VSS bitcell_6t
XC16_16 BL16 BLB16 WL16 VDD VSS bitcell_6t
XC16_17 BL17 BLB17 WL16 VDD VSS bitcell_6t
XC16_18 BL18 BLB18 WL16 VDD VSS bitcell_6t
XC16_19 BL19 BLB19 WL16 VDD VSS bitcell_6t
XC16_20 BL20 BLB20 WL16 VDD VSS bitcell_6t
XC16_21 BL21 BLB21 WL16 VDD VSS bitcell_6t
XC16_22 BL22 BLB22 WL16 VDD VSS bitcell_6t
XC16_23 BL23 BLB23 WL16 VDD VSS bitcell_6t
XC16_24 BL24 BLB24 WL16 VDD VSS bitcell_6t
XC16_25 BL25 BLB25 WL16 VDD VSS bitcell_6t
XC16_26 BL26 BLB26 WL16 VDD VSS bitcell_6t
XC16_27 BL27 BLB27 WL16 VDD VSS bitcell_6t
XC16_28 BL28 BLB28 WL16 VDD VSS bitcell_6t
XC16_29 BL29 BLB29 WL16 VDD VSS bitcell_6t
XC16_30 BL30 BLB30 WL16 VDD VSS bitcell_6t
XC16_31 BL31 BLB31 WL16 VDD VSS bitcell_6t
XC16_32 BL32 BLB32 WL16 VDD VSS bitcell_6t
XC16_33 BL33 BLB33 WL16 VDD VSS bitcell_6t
XC16_34 BL34 BLB34 WL16 VDD VSS bitcell_6t
XC16_35 BL35 BLB35 WL16 VDD VSS bitcell_6t
XC16_36 BL36 BLB36 WL16 VDD VSS bitcell_6t
XC16_37 BL37 BLB37 WL16 VDD VSS bitcell_6t
XC16_38 BL38 BLB38 WL16 VDD VSS bitcell_6t
XC16_39 BL39 BLB39 WL16 VDD VSS bitcell_6t
XC16_40 BL40 BLB40 WL16 VDD VSS bitcell_6t
XC16_41 BL41 BLB41 WL16 VDD VSS bitcell_6t
XC16_42 BL42 BLB42 WL16 VDD VSS bitcell_6t
XC16_43 BL43 BLB43 WL16 VDD VSS bitcell_6t
XC16_44 BL44 BLB44 WL16 VDD VSS bitcell_6t
XC16_45 BL45 BLB45 WL16 VDD VSS bitcell_6t
XC16_46 BL46 BLB46 WL16 VDD VSS bitcell_6t
XC16_47 BL47 BLB47 WL16 VDD VSS bitcell_6t
XC16_48 BL48 BLB48 WL16 VDD VSS bitcell_6t
XC16_49 BL49 BLB49 WL16 VDD VSS bitcell_6t
XC16_50 BL50 BLB50 WL16 VDD VSS bitcell_6t
XC16_51 BL51 BLB51 WL16 VDD VSS bitcell_6t
XC16_52 BL52 BLB52 WL16 VDD VSS bitcell_6t
XC16_53 BL53 BLB53 WL16 VDD VSS bitcell_6t
XC16_54 BL54 BLB54 WL16 VDD VSS bitcell_6t
XC16_55 BL55 BLB55 WL16 VDD VSS bitcell_6t
XC16_56 BL56 BLB56 WL16 VDD VSS bitcell_6t
XC16_57 BL57 BLB57 WL16 VDD VSS bitcell_6t
XC16_58 BL58 BLB58 WL16 VDD VSS bitcell_6t
XC16_59 BL59 BLB59 WL16 VDD VSS bitcell_6t
XC16_60 BL60 BLB60 WL16 VDD VSS bitcell_6t
XC16_61 BL61 BLB61 WL16 VDD VSS bitcell_6t
XC16_62 BL62 BLB62 WL16 VDD VSS bitcell_6t
XC16_63 BL63 BLB63 WL16 VDD VSS bitcell_6t
XC16_64 BL64 BLB64 WL16 VDD VSS bitcell_6t
XC16_65 BL65 BLB65 WL16 VDD VSS bitcell_6t
XC16_66 BL66 BLB66 WL16 VDD VSS bitcell_6t
XC16_67 BL67 BLB67 WL16 VDD VSS bitcell_6t
XC16_68 BL68 BLB68 WL16 VDD VSS bitcell_6t
XC16_69 BL69 BLB69 WL16 VDD VSS bitcell_6t
XC16_70 BL70 BLB70 WL16 VDD VSS bitcell_6t
XC16_71 BL71 BLB71 WL16 VDD VSS bitcell_6t
XC16_72 BL72 BLB72 WL16 VDD VSS bitcell_6t
XC16_73 BL73 BLB73 WL16 VDD VSS bitcell_6t
XC16_74 BL74 BLB74 WL16 VDD VSS bitcell_6t
XC16_75 BL75 BLB75 WL16 VDD VSS bitcell_6t
XC16_76 BL76 BLB76 WL16 VDD VSS bitcell_6t
XC16_77 BL77 BLB77 WL16 VDD VSS bitcell_6t
XC16_78 BL78 BLB78 WL16 VDD VSS bitcell_6t
XC16_79 BL79 BLB79 WL16 VDD VSS bitcell_6t
XC16_80 BL80 BLB80 WL16 VDD VSS bitcell_6t
XC16_81 BL81 BLB81 WL16 VDD VSS bitcell_6t
XC16_82 BL82 BLB82 WL16 VDD VSS bitcell_6t
XC16_83 BL83 BLB83 WL16 VDD VSS bitcell_6t
XC16_84 BL84 BLB84 WL16 VDD VSS bitcell_6t
XC16_85 BL85 BLB85 WL16 VDD VSS bitcell_6t
XC16_86 BL86 BLB86 WL16 VDD VSS bitcell_6t
XC16_87 BL87 BLB87 WL16 VDD VSS bitcell_6t
XC16_88 BL88 BLB88 WL16 VDD VSS bitcell_6t
XC16_89 BL89 BLB89 WL16 VDD VSS bitcell_6t
XC16_90 BL90 BLB90 WL16 VDD VSS bitcell_6t
XC16_91 BL91 BLB91 WL16 VDD VSS bitcell_6t
XC16_92 BL92 BLB92 WL16 VDD VSS bitcell_6t
XC16_93 BL93 BLB93 WL16 VDD VSS bitcell_6t
XC16_94 BL94 BLB94 WL16 VDD VSS bitcell_6t
XC16_95 BL95 BLB95 WL16 VDD VSS bitcell_6t
XC16_96 BL96 BLB96 WL16 VDD VSS bitcell_6t
XC16_97 BL97 BLB97 WL16 VDD VSS bitcell_6t
XC16_98 BL98 BLB98 WL16 VDD VSS bitcell_6t
XC16_99 BL99 BLB99 WL16 VDD VSS bitcell_6t
XC16_100 BL100 BLB100 WL16 VDD VSS bitcell_6t
XC16_101 BL101 BLB101 WL16 VDD VSS bitcell_6t
XC16_102 BL102 BLB102 WL16 VDD VSS bitcell_6t
XC16_103 BL103 BLB103 WL16 VDD VSS bitcell_6t
XC16_104 BL104 BLB104 WL16 VDD VSS bitcell_6t
XC16_105 BL105 BLB105 WL16 VDD VSS bitcell_6t
XC16_106 BL106 BLB106 WL16 VDD VSS bitcell_6t
XC16_107 BL107 BLB107 WL16 VDD VSS bitcell_6t
XC16_108 BL108 BLB108 WL16 VDD VSS bitcell_6t
XC16_109 BL109 BLB109 WL16 VDD VSS bitcell_6t
XC16_110 BL110 BLB110 WL16 VDD VSS bitcell_6t
XC16_111 BL111 BLB111 WL16 VDD VSS bitcell_6t
XC16_112 BL112 BLB112 WL16 VDD VSS bitcell_6t
XC16_113 BL113 BLB113 WL16 VDD VSS bitcell_6t
XC16_114 BL114 BLB114 WL16 VDD VSS bitcell_6t
XC16_115 BL115 BLB115 WL16 VDD VSS bitcell_6t
XC16_116 BL116 BLB116 WL16 VDD VSS bitcell_6t
XC16_117 BL117 BLB117 WL16 VDD VSS bitcell_6t
XC16_118 BL118 BLB118 WL16 VDD VSS bitcell_6t
XC16_119 BL119 BLB119 WL16 VDD VSS bitcell_6t
XC16_120 BL120 BLB120 WL16 VDD VSS bitcell_6t
XC16_121 BL121 BLB121 WL16 VDD VSS bitcell_6t
XC16_122 BL122 BLB122 WL16 VDD VSS bitcell_6t
XC16_123 BL123 BLB123 WL16 VDD VSS bitcell_6t
XC16_124 BL124 BLB124 WL16 VDD VSS bitcell_6t
XC16_125 BL125 BLB125 WL16 VDD VSS bitcell_6t
XC16_126 BL126 BLB126 WL16 VDD VSS bitcell_6t
XC16_127 BL127 BLB127 WL16 VDD VSS bitcell_6t
XC17_0 BL0 BLB0 WL17 VDD VSS bitcell_6t
XC17_1 BL1 BLB1 WL17 VDD VSS bitcell_6t
XC17_2 BL2 BLB2 WL17 VDD VSS bitcell_6t
XC17_3 BL3 BLB3 WL17 VDD VSS bitcell_6t
XC17_4 BL4 BLB4 WL17 VDD VSS bitcell_6t
XC17_5 BL5 BLB5 WL17 VDD VSS bitcell_6t
XC17_6 BL6 BLB6 WL17 VDD VSS bitcell_6t
XC17_7 BL7 BLB7 WL17 VDD VSS bitcell_6t
XC17_8 BL8 BLB8 WL17 VDD VSS bitcell_6t
XC17_9 BL9 BLB9 WL17 VDD VSS bitcell_6t
XC17_10 BL10 BLB10 WL17 VDD VSS bitcell_6t
XC17_11 BL11 BLB11 WL17 VDD VSS bitcell_6t
XC17_12 BL12 BLB12 WL17 VDD VSS bitcell_6t
XC17_13 BL13 BLB13 WL17 VDD VSS bitcell_6t
XC17_14 BL14 BLB14 WL17 VDD VSS bitcell_6t
XC17_15 BL15 BLB15 WL17 VDD VSS bitcell_6t
XC17_16 BL16 BLB16 WL17 VDD VSS bitcell_6t
XC17_17 BL17 BLB17 WL17 VDD VSS bitcell_6t
XC17_18 BL18 BLB18 WL17 VDD VSS bitcell_6t
XC17_19 BL19 BLB19 WL17 VDD VSS bitcell_6t
XC17_20 BL20 BLB20 WL17 VDD VSS bitcell_6t
XC17_21 BL21 BLB21 WL17 VDD VSS bitcell_6t
XC17_22 BL22 BLB22 WL17 VDD VSS bitcell_6t
XC17_23 BL23 BLB23 WL17 VDD VSS bitcell_6t
XC17_24 BL24 BLB24 WL17 VDD VSS bitcell_6t
XC17_25 BL25 BLB25 WL17 VDD VSS bitcell_6t
XC17_26 BL26 BLB26 WL17 VDD VSS bitcell_6t
XC17_27 BL27 BLB27 WL17 VDD VSS bitcell_6t
XC17_28 BL28 BLB28 WL17 VDD VSS bitcell_6t
XC17_29 BL29 BLB29 WL17 VDD VSS bitcell_6t
XC17_30 BL30 BLB30 WL17 VDD VSS bitcell_6t
XC17_31 BL31 BLB31 WL17 VDD VSS bitcell_6t
XC17_32 BL32 BLB32 WL17 VDD VSS bitcell_6t
XC17_33 BL33 BLB33 WL17 VDD VSS bitcell_6t
XC17_34 BL34 BLB34 WL17 VDD VSS bitcell_6t
XC17_35 BL35 BLB35 WL17 VDD VSS bitcell_6t
XC17_36 BL36 BLB36 WL17 VDD VSS bitcell_6t
XC17_37 BL37 BLB37 WL17 VDD VSS bitcell_6t
XC17_38 BL38 BLB38 WL17 VDD VSS bitcell_6t
XC17_39 BL39 BLB39 WL17 VDD VSS bitcell_6t
XC17_40 BL40 BLB40 WL17 VDD VSS bitcell_6t
XC17_41 BL41 BLB41 WL17 VDD VSS bitcell_6t
XC17_42 BL42 BLB42 WL17 VDD VSS bitcell_6t
XC17_43 BL43 BLB43 WL17 VDD VSS bitcell_6t
XC17_44 BL44 BLB44 WL17 VDD VSS bitcell_6t
XC17_45 BL45 BLB45 WL17 VDD VSS bitcell_6t
XC17_46 BL46 BLB46 WL17 VDD VSS bitcell_6t
XC17_47 BL47 BLB47 WL17 VDD VSS bitcell_6t
XC17_48 BL48 BLB48 WL17 VDD VSS bitcell_6t
XC17_49 BL49 BLB49 WL17 VDD VSS bitcell_6t
XC17_50 BL50 BLB50 WL17 VDD VSS bitcell_6t
XC17_51 BL51 BLB51 WL17 VDD VSS bitcell_6t
XC17_52 BL52 BLB52 WL17 VDD VSS bitcell_6t
XC17_53 BL53 BLB53 WL17 VDD VSS bitcell_6t
XC17_54 BL54 BLB54 WL17 VDD VSS bitcell_6t
XC17_55 BL55 BLB55 WL17 VDD VSS bitcell_6t
XC17_56 BL56 BLB56 WL17 VDD VSS bitcell_6t
XC17_57 BL57 BLB57 WL17 VDD VSS bitcell_6t
XC17_58 BL58 BLB58 WL17 VDD VSS bitcell_6t
XC17_59 BL59 BLB59 WL17 VDD VSS bitcell_6t
XC17_60 BL60 BLB60 WL17 VDD VSS bitcell_6t
XC17_61 BL61 BLB61 WL17 VDD VSS bitcell_6t
XC17_62 BL62 BLB62 WL17 VDD VSS bitcell_6t
XC17_63 BL63 BLB63 WL17 VDD VSS bitcell_6t
XC17_64 BL64 BLB64 WL17 VDD VSS bitcell_6t
XC17_65 BL65 BLB65 WL17 VDD VSS bitcell_6t
XC17_66 BL66 BLB66 WL17 VDD VSS bitcell_6t
XC17_67 BL67 BLB67 WL17 VDD VSS bitcell_6t
XC17_68 BL68 BLB68 WL17 VDD VSS bitcell_6t
XC17_69 BL69 BLB69 WL17 VDD VSS bitcell_6t
XC17_70 BL70 BLB70 WL17 VDD VSS bitcell_6t
XC17_71 BL71 BLB71 WL17 VDD VSS bitcell_6t
XC17_72 BL72 BLB72 WL17 VDD VSS bitcell_6t
XC17_73 BL73 BLB73 WL17 VDD VSS bitcell_6t
XC17_74 BL74 BLB74 WL17 VDD VSS bitcell_6t
XC17_75 BL75 BLB75 WL17 VDD VSS bitcell_6t
XC17_76 BL76 BLB76 WL17 VDD VSS bitcell_6t
XC17_77 BL77 BLB77 WL17 VDD VSS bitcell_6t
XC17_78 BL78 BLB78 WL17 VDD VSS bitcell_6t
XC17_79 BL79 BLB79 WL17 VDD VSS bitcell_6t
XC17_80 BL80 BLB80 WL17 VDD VSS bitcell_6t
XC17_81 BL81 BLB81 WL17 VDD VSS bitcell_6t
XC17_82 BL82 BLB82 WL17 VDD VSS bitcell_6t
XC17_83 BL83 BLB83 WL17 VDD VSS bitcell_6t
XC17_84 BL84 BLB84 WL17 VDD VSS bitcell_6t
XC17_85 BL85 BLB85 WL17 VDD VSS bitcell_6t
XC17_86 BL86 BLB86 WL17 VDD VSS bitcell_6t
XC17_87 BL87 BLB87 WL17 VDD VSS bitcell_6t
XC17_88 BL88 BLB88 WL17 VDD VSS bitcell_6t
XC17_89 BL89 BLB89 WL17 VDD VSS bitcell_6t
XC17_90 BL90 BLB90 WL17 VDD VSS bitcell_6t
XC17_91 BL91 BLB91 WL17 VDD VSS bitcell_6t
XC17_92 BL92 BLB92 WL17 VDD VSS bitcell_6t
XC17_93 BL93 BLB93 WL17 VDD VSS bitcell_6t
XC17_94 BL94 BLB94 WL17 VDD VSS bitcell_6t
XC17_95 BL95 BLB95 WL17 VDD VSS bitcell_6t
XC17_96 BL96 BLB96 WL17 VDD VSS bitcell_6t
XC17_97 BL97 BLB97 WL17 VDD VSS bitcell_6t
XC17_98 BL98 BLB98 WL17 VDD VSS bitcell_6t
XC17_99 BL99 BLB99 WL17 VDD VSS bitcell_6t
XC17_100 BL100 BLB100 WL17 VDD VSS bitcell_6t
XC17_101 BL101 BLB101 WL17 VDD VSS bitcell_6t
XC17_102 BL102 BLB102 WL17 VDD VSS bitcell_6t
XC17_103 BL103 BLB103 WL17 VDD VSS bitcell_6t
XC17_104 BL104 BLB104 WL17 VDD VSS bitcell_6t
XC17_105 BL105 BLB105 WL17 VDD VSS bitcell_6t
XC17_106 BL106 BLB106 WL17 VDD VSS bitcell_6t
XC17_107 BL107 BLB107 WL17 VDD VSS bitcell_6t
XC17_108 BL108 BLB108 WL17 VDD VSS bitcell_6t
XC17_109 BL109 BLB109 WL17 VDD VSS bitcell_6t
XC17_110 BL110 BLB110 WL17 VDD VSS bitcell_6t
XC17_111 BL111 BLB111 WL17 VDD VSS bitcell_6t
XC17_112 BL112 BLB112 WL17 VDD VSS bitcell_6t
XC17_113 BL113 BLB113 WL17 VDD VSS bitcell_6t
XC17_114 BL114 BLB114 WL17 VDD VSS bitcell_6t
XC17_115 BL115 BLB115 WL17 VDD VSS bitcell_6t
XC17_116 BL116 BLB116 WL17 VDD VSS bitcell_6t
XC17_117 BL117 BLB117 WL17 VDD VSS bitcell_6t
XC17_118 BL118 BLB118 WL17 VDD VSS bitcell_6t
XC17_119 BL119 BLB119 WL17 VDD VSS bitcell_6t
XC17_120 BL120 BLB120 WL17 VDD VSS bitcell_6t
XC17_121 BL121 BLB121 WL17 VDD VSS bitcell_6t
XC17_122 BL122 BLB122 WL17 VDD VSS bitcell_6t
XC17_123 BL123 BLB123 WL17 VDD VSS bitcell_6t
XC17_124 BL124 BLB124 WL17 VDD VSS bitcell_6t
XC17_125 BL125 BLB125 WL17 VDD VSS bitcell_6t
XC17_126 BL126 BLB126 WL17 VDD VSS bitcell_6t
XC17_127 BL127 BLB127 WL17 VDD VSS bitcell_6t
XC18_0 BL0 BLB0 WL18 VDD VSS bitcell_6t
XC18_1 BL1 BLB1 WL18 VDD VSS bitcell_6t
XC18_2 BL2 BLB2 WL18 VDD VSS bitcell_6t
XC18_3 BL3 BLB3 WL18 VDD VSS bitcell_6t
XC18_4 BL4 BLB4 WL18 VDD VSS bitcell_6t
XC18_5 BL5 BLB5 WL18 VDD VSS bitcell_6t
XC18_6 BL6 BLB6 WL18 VDD VSS bitcell_6t
XC18_7 BL7 BLB7 WL18 VDD VSS bitcell_6t
XC18_8 BL8 BLB8 WL18 VDD VSS bitcell_6t
XC18_9 BL9 BLB9 WL18 VDD VSS bitcell_6t
XC18_10 BL10 BLB10 WL18 VDD VSS bitcell_6t
XC18_11 BL11 BLB11 WL18 VDD VSS bitcell_6t
XC18_12 BL12 BLB12 WL18 VDD VSS bitcell_6t
XC18_13 BL13 BLB13 WL18 VDD VSS bitcell_6t
XC18_14 BL14 BLB14 WL18 VDD VSS bitcell_6t
XC18_15 BL15 BLB15 WL18 VDD VSS bitcell_6t
XC18_16 BL16 BLB16 WL18 VDD VSS bitcell_6t
XC18_17 BL17 BLB17 WL18 VDD VSS bitcell_6t
XC18_18 BL18 BLB18 WL18 VDD VSS bitcell_6t
XC18_19 BL19 BLB19 WL18 VDD VSS bitcell_6t
XC18_20 BL20 BLB20 WL18 VDD VSS bitcell_6t
XC18_21 BL21 BLB21 WL18 VDD VSS bitcell_6t
XC18_22 BL22 BLB22 WL18 VDD VSS bitcell_6t
XC18_23 BL23 BLB23 WL18 VDD VSS bitcell_6t
XC18_24 BL24 BLB24 WL18 VDD VSS bitcell_6t
XC18_25 BL25 BLB25 WL18 VDD VSS bitcell_6t
XC18_26 BL26 BLB26 WL18 VDD VSS bitcell_6t
XC18_27 BL27 BLB27 WL18 VDD VSS bitcell_6t
XC18_28 BL28 BLB28 WL18 VDD VSS bitcell_6t
XC18_29 BL29 BLB29 WL18 VDD VSS bitcell_6t
XC18_30 BL30 BLB30 WL18 VDD VSS bitcell_6t
XC18_31 BL31 BLB31 WL18 VDD VSS bitcell_6t
XC18_32 BL32 BLB32 WL18 VDD VSS bitcell_6t
XC18_33 BL33 BLB33 WL18 VDD VSS bitcell_6t
XC18_34 BL34 BLB34 WL18 VDD VSS bitcell_6t
XC18_35 BL35 BLB35 WL18 VDD VSS bitcell_6t
XC18_36 BL36 BLB36 WL18 VDD VSS bitcell_6t
XC18_37 BL37 BLB37 WL18 VDD VSS bitcell_6t
XC18_38 BL38 BLB38 WL18 VDD VSS bitcell_6t
XC18_39 BL39 BLB39 WL18 VDD VSS bitcell_6t
XC18_40 BL40 BLB40 WL18 VDD VSS bitcell_6t
XC18_41 BL41 BLB41 WL18 VDD VSS bitcell_6t
XC18_42 BL42 BLB42 WL18 VDD VSS bitcell_6t
XC18_43 BL43 BLB43 WL18 VDD VSS bitcell_6t
XC18_44 BL44 BLB44 WL18 VDD VSS bitcell_6t
XC18_45 BL45 BLB45 WL18 VDD VSS bitcell_6t
XC18_46 BL46 BLB46 WL18 VDD VSS bitcell_6t
XC18_47 BL47 BLB47 WL18 VDD VSS bitcell_6t
XC18_48 BL48 BLB48 WL18 VDD VSS bitcell_6t
XC18_49 BL49 BLB49 WL18 VDD VSS bitcell_6t
XC18_50 BL50 BLB50 WL18 VDD VSS bitcell_6t
XC18_51 BL51 BLB51 WL18 VDD VSS bitcell_6t
XC18_52 BL52 BLB52 WL18 VDD VSS bitcell_6t
XC18_53 BL53 BLB53 WL18 VDD VSS bitcell_6t
XC18_54 BL54 BLB54 WL18 VDD VSS bitcell_6t
XC18_55 BL55 BLB55 WL18 VDD VSS bitcell_6t
XC18_56 BL56 BLB56 WL18 VDD VSS bitcell_6t
XC18_57 BL57 BLB57 WL18 VDD VSS bitcell_6t
XC18_58 BL58 BLB58 WL18 VDD VSS bitcell_6t
XC18_59 BL59 BLB59 WL18 VDD VSS bitcell_6t
XC18_60 BL60 BLB60 WL18 VDD VSS bitcell_6t
XC18_61 BL61 BLB61 WL18 VDD VSS bitcell_6t
XC18_62 BL62 BLB62 WL18 VDD VSS bitcell_6t
XC18_63 BL63 BLB63 WL18 VDD VSS bitcell_6t
XC18_64 BL64 BLB64 WL18 VDD VSS bitcell_6t
XC18_65 BL65 BLB65 WL18 VDD VSS bitcell_6t
XC18_66 BL66 BLB66 WL18 VDD VSS bitcell_6t
XC18_67 BL67 BLB67 WL18 VDD VSS bitcell_6t
XC18_68 BL68 BLB68 WL18 VDD VSS bitcell_6t
XC18_69 BL69 BLB69 WL18 VDD VSS bitcell_6t
XC18_70 BL70 BLB70 WL18 VDD VSS bitcell_6t
XC18_71 BL71 BLB71 WL18 VDD VSS bitcell_6t
XC18_72 BL72 BLB72 WL18 VDD VSS bitcell_6t
XC18_73 BL73 BLB73 WL18 VDD VSS bitcell_6t
XC18_74 BL74 BLB74 WL18 VDD VSS bitcell_6t
XC18_75 BL75 BLB75 WL18 VDD VSS bitcell_6t
XC18_76 BL76 BLB76 WL18 VDD VSS bitcell_6t
XC18_77 BL77 BLB77 WL18 VDD VSS bitcell_6t
XC18_78 BL78 BLB78 WL18 VDD VSS bitcell_6t
XC18_79 BL79 BLB79 WL18 VDD VSS bitcell_6t
XC18_80 BL80 BLB80 WL18 VDD VSS bitcell_6t
XC18_81 BL81 BLB81 WL18 VDD VSS bitcell_6t
XC18_82 BL82 BLB82 WL18 VDD VSS bitcell_6t
XC18_83 BL83 BLB83 WL18 VDD VSS bitcell_6t
XC18_84 BL84 BLB84 WL18 VDD VSS bitcell_6t
XC18_85 BL85 BLB85 WL18 VDD VSS bitcell_6t
XC18_86 BL86 BLB86 WL18 VDD VSS bitcell_6t
XC18_87 BL87 BLB87 WL18 VDD VSS bitcell_6t
XC18_88 BL88 BLB88 WL18 VDD VSS bitcell_6t
XC18_89 BL89 BLB89 WL18 VDD VSS bitcell_6t
XC18_90 BL90 BLB90 WL18 VDD VSS bitcell_6t
XC18_91 BL91 BLB91 WL18 VDD VSS bitcell_6t
XC18_92 BL92 BLB92 WL18 VDD VSS bitcell_6t
XC18_93 BL93 BLB93 WL18 VDD VSS bitcell_6t
XC18_94 BL94 BLB94 WL18 VDD VSS bitcell_6t
XC18_95 BL95 BLB95 WL18 VDD VSS bitcell_6t
XC18_96 BL96 BLB96 WL18 VDD VSS bitcell_6t
XC18_97 BL97 BLB97 WL18 VDD VSS bitcell_6t
XC18_98 BL98 BLB98 WL18 VDD VSS bitcell_6t
XC18_99 BL99 BLB99 WL18 VDD VSS bitcell_6t
XC18_100 BL100 BLB100 WL18 VDD VSS bitcell_6t
XC18_101 BL101 BLB101 WL18 VDD VSS bitcell_6t
XC18_102 BL102 BLB102 WL18 VDD VSS bitcell_6t
XC18_103 BL103 BLB103 WL18 VDD VSS bitcell_6t
XC18_104 BL104 BLB104 WL18 VDD VSS bitcell_6t
XC18_105 BL105 BLB105 WL18 VDD VSS bitcell_6t
XC18_106 BL106 BLB106 WL18 VDD VSS bitcell_6t
XC18_107 BL107 BLB107 WL18 VDD VSS bitcell_6t
XC18_108 BL108 BLB108 WL18 VDD VSS bitcell_6t
XC18_109 BL109 BLB109 WL18 VDD VSS bitcell_6t
XC18_110 BL110 BLB110 WL18 VDD VSS bitcell_6t
XC18_111 BL111 BLB111 WL18 VDD VSS bitcell_6t
XC18_112 BL112 BLB112 WL18 VDD VSS bitcell_6t
XC18_113 BL113 BLB113 WL18 VDD VSS bitcell_6t
XC18_114 BL114 BLB114 WL18 VDD VSS bitcell_6t
XC18_115 BL115 BLB115 WL18 VDD VSS bitcell_6t
XC18_116 BL116 BLB116 WL18 VDD VSS bitcell_6t
XC18_117 BL117 BLB117 WL18 VDD VSS bitcell_6t
XC18_118 BL118 BLB118 WL18 VDD VSS bitcell_6t
XC18_119 BL119 BLB119 WL18 VDD VSS bitcell_6t
XC18_120 BL120 BLB120 WL18 VDD VSS bitcell_6t
XC18_121 BL121 BLB121 WL18 VDD VSS bitcell_6t
XC18_122 BL122 BLB122 WL18 VDD VSS bitcell_6t
XC18_123 BL123 BLB123 WL18 VDD VSS bitcell_6t
XC18_124 BL124 BLB124 WL18 VDD VSS bitcell_6t
XC18_125 BL125 BLB125 WL18 VDD VSS bitcell_6t
XC18_126 BL126 BLB126 WL18 VDD VSS bitcell_6t
XC18_127 BL127 BLB127 WL18 VDD VSS bitcell_6t
XC19_0 BL0 BLB0 WL19 VDD VSS bitcell_6t
XC19_1 BL1 BLB1 WL19 VDD VSS bitcell_6t
XC19_2 BL2 BLB2 WL19 VDD VSS bitcell_6t
XC19_3 BL3 BLB3 WL19 VDD VSS bitcell_6t
XC19_4 BL4 BLB4 WL19 VDD VSS bitcell_6t
XC19_5 BL5 BLB5 WL19 VDD VSS bitcell_6t
XC19_6 BL6 BLB6 WL19 VDD VSS bitcell_6t
XC19_7 BL7 BLB7 WL19 VDD VSS bitcell_6t
XC19_8 BL8 BLB8 WL19 VDD VSS bitcell_6t
XC19_9 BL9 BLB9 WL19 VDD VSS bitcell_6t
XC19_10 BL10 BLB10 WL19 VDD VSS bitcell_6t
XC19_11 BL11 BLB11 WL19 VDD VSS bitcell_6t
XC19_12 BL12 BLB12 WL19 VDD VSS bitcell_6t
XC19_13 BL13 BLB13 WL19 VDD VSS bitcell_6t
XC19_14 BL14 BLB14 WL19 VDD VSS bitcell_6t
XC19_15 BL15 BLB15 WL19 VDD VSS bitcell_6t
XC19_16 BL16 BLB16 WL19 VDD VSS bitcell_6t
XC19_17 BL17 BLB17 WL19 VDD VSS bitcell_6t
XC19_18 BL18 BLB18 WL19 VDD VSS bitcell_6t
XC19_19 BL19 BLB19 WL19 VDD VSS bitcell_6t
XC19_20 BL20 BLB20 WL19 VDD VSS bitcell_6t
XC19_21 BL21 BLB21 WL19 VDD VSS bitcell_6t
XC19_22 BL22 BLB22 WL19 VDD VSS bitcell_6t
XC19_23 BL23 BLB23 WL19 VDD VSS bitcell_6t
XC19_24 BL24 BLB24 WL19 VDD VSS bitcell_6t
XC19_25 BL25 BLB25 WL19 VDD VSS bitcell_6t
XC19_26 BL26 BLB26 WL19 VDD VSS bitcell_6t
XC19_27 BL27 BLB27 WL19 VDD VSS bitcell_6t
XC19_28 BL28 BLB28 WL19 VDD VSS bitcell_6t
XC19_29 BL29 BLB29 WL19 VDD VSS bitcell_6t
XC19_30 BL30 BLB30 WL19 VDD VSS bitcell_6t
XC19_31 BL31 BLB31 WL19 VDD VSS bitcell_6t
XC19_32 BL32 BLB32 WL19 VDD VSS bitcell_6t
XC19_33 BL33 BLB33 WL19 VDD VSS bitcell_6t
XC19_34 BL34 BLB34 WL19 VDD VSS bitcell_6t
XC19_35 BL35 BLB35 WL19 VDD VSS bitcell_6t
XC19_36 BL36 BLB36 WL19 VDD VSS bitcell_6t
XC19_37 BL37 BLB37 WL19 VDD VSS bitcell_6t
XC19_38 BL38 BLB38 WL19 VDD VSS bitcell_6t
XC19_39 BL39 BLB39 WL19 VDD VSS bitcell_6t
XC19_40 BL40 BLB40 WL19 VDD VSS bitcell_6t
XC19_41 BL41 BLB41 WL19 VDD VSS bitcell_6t
XC19_42 BL42 BLB42 WL19 VDD VSS bitcell_6t
XC19_43 BL43 BLB43 WL19 VDD VSS bitcell_6t
XC19_44 BL44 BLB44 WL19 VDD VSS bitcell_6t
XC19_45 BL45 BLB45 WL19 VDD VSS bitcell_6t
XC19_46 BL46 BLB46 WL19 VDD VSS bitcell_6t
XC19_47 BL47 BLB47 WL19 VDD VSS bitcell_6t
XC19_48 BL48 BLB48 WL19 VDD VSS bitcell_6t
XC19_49 BL49 BLB49 WL19 VDD VSS bitcell_6t
XC19_50 BL50 BLB50 WL19 VDD VSS bitcell_6t
XC19_51 BL51 BLB51 WL19 VDD VSS bitcell_6t
XC19_52 BL52 BLB52 WL19 VDD VSS bitcell_6t
XC19_53 BL53 BLB53 WL19 VDD VSS bitcell_6t
XC19_54 BL54 BLB54 WL19 VDD VSS bitcell_6t
XC19_55 BL55 BLB55 WL19 VDD VSS bitcell_6t
XC19_56 BL56 BLB56 WL19 VDD VSS bitcell_6t
XC19_57 BL57 BLB57 WL19 VDD VSS bitcell_6t
XC19_58 BL58 BLB58 WL19 VDD VSS bitcell_6t
XC19_59 BL59 BLB59 WL19 VDD VSS bitcell_6t
XC19_60 BL60 BLB60 WL19 VDD VSS bitcell_6t
XC19_61 BL61 BLB61 WL19 VDD VSS bitcell_6t
XC19_62 BL62 BLB62 WL19 VDD VSS bitcell_6t
XC19_63 BL63 BLB63 WL19 VDD VSS bitcell_6t
XC19_64 BL64 BLB64 WL19 VDD VSS bitcell_6t
XC19_65 BL65 BLB65 WL19 VDD VSS bitcell_6t
XC19_66 BL66 BLB66 WL19 VDD VSS bitcell_6t
XC19_67 BL67 BLB67 WL19 VDD VSS bitcell_6t
XC19_68 BL68 BLB68 WL19 VDD VSS bitcell_6t
XC19_69 BL69 BLB69 WL19 VDD VSS bitcell_6t
XC19_70 BL70 BLB70 WL19 VDD VSS bitcell_6t
XC19_71 BL71 BLB71 WL19 VDD VSS bitcell_6t
XC19_72 BL72 BLB72 WL19 VDD VSS bitcell_6t
XC19_73 BL73 BLB73 WL19 VDD VSS bitcell_6t
XC19_74 BL74 BLB74 WL19 VDD VSS bitcell_6t
XC19_75 BL75 BLB75 WL19 VDD VSS bitcell_6t
XC19_76 BL76 BLB76 WL19 VDD VSS bitcell_6t
XC19_77 BL77 BLB77 WL19 VDD VSS bitcell_6t
XC19_78 BL78 BLB78 WL19 VDD VSS bitcell_6t
XC19_79 BL79 BLB79 WL19 VDD VSS bitcell_6t
XC19_80 BL80 BLB80 WL19 VDD VSS bitcell_6t
XC19_81 BL81 BLB81 WL19 VDD VSS bitcell_6t
XC19_82 BL82 BLB82 WL19 VDD VSS bitcell_6t
XC19_83 BL83 BLB83 WL19 VDD VSS bitcell_6t
XC19_84 BL84 BLB84 WL19 VDD VSS bitcell_6t
XC19_85 BL85 BLB85 WL19 VDD VSS bitcell_6t
XC19_86 BL86 BLB86 WL19 VDD VSS bitcell_6t
XC19_87 BL87 BLB87 WL19 VDD VSS bitcell_6t
XC19_88 BL88 BLB88 WL19 VDD VSS bitcell_6t
XC19_89 BL89 BLB89 WL19 VDD VSS bitcell_6t
XC19_90 BL90 BLB90 WL19 VDD VSS bitcell_6t
XC19_91 BL91 BLB91 WL19 VDD VSS bitcell_6t
XC19_92 BL92 BLB92 WL19 VDD VSS bitcell_6t
XC19_93 BL93 BLB93 WL19 VDD VSS bitcell_6t
XC19_94 BL94 BLB94 WL19 VDD VSS bitcell_6t
XC19_95 BL95 BLB95 WL19 VDD VSS bitcell_6t
XC19_96 BL96 BLB96 WL19 VDD VSS bitcell_6t
XC19_97 BL97 BLB97 WL19 VDD VSS bitcell_6t
XC19_98 BL98 BLB98 WL19 VDD VSS bitcell_6t
XC19_99 BL99 BLB99 WL19 VDD VSS bitcell_6t
XC19_100 BL100 BLB100 WL19 VDD VSS bitcell_6t
XC19_101 BL101 BLB101 WL19 VDD VSS bitcell_6t
XC19_102 BL102 BLB102 WL19 VDD VSS bitcell_6t
XC19_103 BL103 BLB103 WL19 VDD VSS bitcell_6t
XC19_104 BL104 BLB104 WL19 VDD VSS bitcell_6t
XC19_105 BL105 BLB105 WL19 VDD VSS bitcell_6t
XC19_106 BL106 BLB106 WL19 VDD VSS bitcell_6t
XC19_107 BL107 BLB107 WL19 VDD VSS bitcell_6t
XC19_108 BL108 BLB108 WL19 VDD VSS bitcell_6t
XC19_109 BL109 BLB109 WL19 VDD VSS bitcell_6t
XC19_110 BL110 BLB110 WL19 VDD VSS bitcell_6t
XC19_111 BL111 BLB111 WL19 VDD VSS bitcell_6t
XC19_112 BL112 BLB112 WL19 VDD VSS bitcell_6t
XC19_113 BL113 BLB113 WL19 VDD VSS bitcell_6t
XC19_114 BL114 BLB114 WL19 VDD VSS bitcell_6t
XC19_115 BL115 BLB115 WL19 VDD VSS bitcell_6t
XC19_116 BL116 BLB116 WL19 VDD VSS bitcell_6t
XC19_117 BL117 BLB117 WL19 VDD VSS bitcell_6t
XC19_118 BL118 BLB118 WL19 VDD VSS bitcell_6t
XC19_119 BL119 BLB119 WL19 VDD VSS bitcell_6t
XC19_120 BL120 BLB120 WL19 VDD VSS bitcell_6t
XC19_121 BL121 BLB121 WL19 VDD VSS bitcell_6t
XC19_122 BL122 BLB122 WL19 VDD VSS bitcell_6t
XC19_123 BL123 BLB123 WL19 VDD VSS bitcell_6t
XC19_124 BL124 BLB124 WL19 VDD VSS bitcell_6t
XC19_125 BL125 BLB125 WL19 VDD VSS bitcell_6t
XC19_126 BL126 BLB126 WL19 VDD VSS bitcell_6t
XC19_127 BL127 BLB127 WL19 VDD VSS bitcell_6t
XC20_0 BL0 BLB0 WL20 VDD VSS bitcell_6t
XC20_1 BL1 BLB1 WL20 VDD VSS bitcell_6t
XC20_2 BL2 BLB2 WL20 VDD VSS bitcell_6t
XC20_3 BL3 BLB3 WL20 VDD VSS bitcell_6t
XC20_4 BL4 BLB4 WL20 VDD VSS bitcell_6t
XC20_5 BL5 BLB5 WL20 VDD VSS bitcell_6t
XC20_6 BL6 BLB6 WL20 VDD VSS bitcell_6t
XC20_7 BL7 BLB7 WL20 VDD VSS bitcell_6t
XC20_8 BL8 BLB8 WL20 VDD VSS bitcell_6t
XC20_9 BL9 BLB9 WL20 VDD VSS bitcell_6t
XC20_10 BL10 BLB10 WL20 VDD VSS bitcell_6t
XC20_11 BL11 BLB11 WL20 VDD VSS bitcell_6t
XC20_12 BL12 BLB12 WL20 VDD VSS bitcell_6t
XC20_13 BL13 BLB13 WL20 VDD VSS bitcell_6t
XC20_14 BL14 BLB14 WL20 VDD VSS bitcell_6t
XC20_15 BL15 BLB15 WL20 VDD VSS bitcell_6t
XC20_16 BL16 BLB16 WL20 VDD VSS bitcell_6t
XC20_17 BL17 BLB17 WL20 VDD VSS bitcell_6t
XC20_18 BL18 BLB18 WL20 VDD VSS bitcell_6t
XC20_19 BL19 BLB19 WL20 VDD VSS bitcell_6t
XC20_20 BL20 BLB20 WL20 VDD VSS bitcell_6t
XC20_21 BL21 BLB21 WL20 VDD VSS bitcell_6t
XC20_22 BL22 BLB22 WL20 VDD VSS bitcell_6t
XC20_23 BL23 BLB23 WL20 VDD VSS bitcell_6t
XC20_24 BL24 BLB24 WL20 VDD VSS bitcell_6t
XC20_25 BL25 BLB25 WL20 VDD VSS bitcell_6t
XC20_26 BL26 BLB26 WL20 VDD VSS bitcell_6t
XC20_27 BL27 BLB27 WL20 VDD VSS bitcell_6t
XC20_28 BL28 BLB28 WL20 VDD VSS bitcell_6t
XC20_29 BL29 BLB29 WL20 VDD VSS bitcell_6t
XC20_30 BL30 BLB30 WL20 VDD VSS bitcell_6t
XC20_31 BL31 BLB31 WL20 VDD VSS bitcell_6t
XC20_32 BL32 BLB32 WL20 VDD VSS bitcell_6t
XC20_33 BL33 BLB33 WL20 VDD VSS bitcell_6t
XC20_34 BL34 BLB34 WL20 VDD VSS bitcell_6t
XC20_35 BL35 BLB35 WL20 VDD VSS bitcell_6t
XC20_36 BL36 BLB36 WL20 VDD VSS bitcell_6t
XC20_37 BL37 BLB37 WL20 VDD VSS bitcell_6t
XC20_38 BL38 BLB38 WL20 VDD VSS bitcell_6t
XC20_39 BL39 BLB39 WL20 VDD VSS bitcell_6t
XC20_40 BL40 BLB40 WL20 VDD VSS bitcell_6t
XC20_41 BL41 BLB41 WL20 VDD VSS bitcell_6t
XC20_42 BL42 BLB42 WL20 VDD VSS bitcell_6t
XC20_43 BL43 BLB43 WL20 VDD VSS bitcell_6t
XC20_44 BL44 BLB44 WL20 VDD VSS bitcell_6t
XC20_45 BL45 BLB45 WL20 VDD VSS bitcell_6t
XC20_46 BL46 BLB46 WL20 VDD VSS bitcell_6t
XC20_47 BL47 BLB47 WL20 VDD VSS bitcell_6t
XC20_48 BL48 BLB48 WL20 VDD VSS bitcell_6t
XC20_49 BL49 BLB49 WL20 VDD VSS bitcell_6t
XC20_50 BL50 BLB50 WL20 VDD VSS bitcell_6t
XC20_51 BL51 BLB51 WL20 VDD VSS bitcell_6t
XC20_52 BL52 BLB52 WL20 VDD VSS bitcell_6t
XC20_53 BL53 BLB53 WL20 VDD VSS bitcell_6t
XC20_54 BL54 BLB54 WL20 VDD VSS bitcell_6t
XC20_55 BL55 BLB55 WL20 VDD VSS bitcell_6t
XC20_56 BL56 BLB56 WL20 VDD VSS bitcell_6t
XC20_57 BL57 BLB57 WL20 VDD VSS bitcell_6t
XC20_58 BL58 BLB58 WL20 VDD VSS bitcell_6t
XC20_59 BL59 BLB59 WL20 VDD VSS bitcell_6t
XC20_60 BL60 BLB60 WL20 VDD VSS bitcell_6t
XC20_61 BL61 BLB61 WL20 VDD VSS bitcell_6t
XC20_62 BL62 BLB62 WL20 VDD VSS bitcell_6t
XC20_63 BL63 BLB63 WL20 VDD VSS bitcell_6t
XC20_64 BL64 BLB64 WL20 VDD VSS bitcell_6t
XC20_65 BL65 BLB65 WL20 VDD VSS bitcell_6t
XC20_66 BL66 BLB66 WL20 VDD VSS bitcell_6t
XC20_67 BL67 BLB67 WL20 VDD VSS bitcell_6t
XC20_68 BL68 BLB68 WL20 VDD VSS bitcell_6t
XC20_69 BL69 BLB69 WL20 VDD VSS bitcell_6t
XC20_70 BL70 BLB70 WL20 VDD VSS bitcell_6t
XC20_71 BL71 BLB71 WL20 VDD VSS bitcell_6t
XC20_72 BL72 BLB72 WL20 VDD VSS bitcell_6t
XC20_73 BL73 BLB73 WL20 VDD VSS bitcell_6t
XC20_74 BL74 BLB74 WL20 VDD VSS bitcell_6t
XC20_75 BL75 BLB75 WL20 VDD VSS bitcell_6t
XC20_76 BL76 BLB76 WL20 VDD VSS bitcell_6t
XC20_77 BL77 BLB77 WL20 VDD VSS bitcell_6t
XC20_78 BL78 BLB78 WL20 VDD VSS bitcell_6t
XC20_79 BL79 BLB79 WL20 VDD VSS bitcell_6t
XC20_80 BL80 BLB80 WL20 VDD VSS bitcell_6t
XC20_81 BL81 BLB81 WL20 VDD VSS bitcell_6t
XC20_82 BL82 BLB82 WL20 VDD VSS bitcell_6t
XC20_83 BL83 BLB83 WL20 VDD VSS bitcell_6t
XC20_84 BL84 BLB84 WL20 VDD VSS bitcell_6t
XC20_85 BL85 BLB85 WL20 VDD VSS bitcell_6t
XC20_86 BL86 BLB86 WL20 VDD VSS bitcell_6t
XC20_87 BL87 BLB87 WL20 VDD VSS bitcell_6t
XC20_88 BL88 BLB88 WL20 VDD VSS bitcell_6t
XC20_89 BL89 BLB89 WL20 VDD VSS bitcell_6t
XC20_90 BL90 BLB90 WL20 VDD VSS bitcell_6t
XC20_91 BL91 BLB91 WL20 VDD VSS bitcell_6t
XC20_92 BL92 BLB92 WL20 VDD VSS bitcell_6t
XC20_93 BL93 BLB93 WL20 VDD VSS bitcell_6t
XC20_94 BL94 BLB94 WL20 VDD VSS bitcell_6t
XC20_95 BL95 BLB95 WL20 VDD VSS bitcell_6t
XC20_96 BL96 BLB96 WL20 VDD VSS bitcell_6t
XC20_97 BL97 BLB97 WL20 VDD VSS bitcell_6t
XC20_98 BL98 BLB98 WL20 VDD VSS bitcell_6t
XC20_99 BL99 BLB99 WL20 VDD VSS bitcell_6t
XC20_100 BL100 BLB100 WL20 VDD VSS bitcell_6t
XC20_101 BL101 BLB101 WL20 VDD VSS bitcell_6t
XC20_102 BL102 BLB102 WL20 VDD VSS bitcell_6t
XC20_103 BL103 BLB103 WL20 VDD VSS bitcell_6t
XC20_104 BL104 BLB104 WL20 VDD VSS bitcell_6t
XC20_105 BL105 BLB105 WL20 VDD VSS bitcell_6t
XC20_106 BL106 BLB106 WL20 VDD VSS bitcell_6t
XC20_107 BL107 BLB107 WL20 VDD VSS bitcell_6t
XC20_108 BL108 BLB108 WL20 VDD VSS bitcell_6t
XC20_109 BL109 BLB109 WL20 VDD VSS bitcell_6t
XC20_110 BL110 BLB110 WL20 VDD VSS bitcell_6t
XC20_111 BL111 BLB111 WL20 VDD VSS bitcell_6t
XC20_112 BL112 BLB112 WL20 VDD VSS bitcell_6t
XC20_113 BL113 BLB113 WL20 VDD VSS bitcell_6t
XC20_114 BL114 BLB114 WL20 VDD VSS bitcell_6t
XC20_115 BL115 BLB115 WL20 VDD VSS bitcell_6t
XC20_116 BL116 BLB116 WL20 VDD VSS bitcell_6t
XC20_117 BL117 BLB117 WL20 VDD VSS bitcell_6t
XC20_118 BL118 BLB118 WL20 VDD VSS bitcell_6t
XC20_119 BL119 BLB119 WL20 VDD VSS bitcell_6t
XC20_120 BL120 BLB120 WL20 VDD VSS bitcell_6t
XC20_121 BL121 BLB121 WL20 VDD VSS bitcell_6t
XC20_122 BL122 BLB122 WL20 VDD VSS bitcell_6t
XC20_123 BL123 BLB123 WL20 VDD VSS bitcell_6t
XC20_124 BL124 BLB124 WL20 VDD VSS bitcell_6t
XC20_125 BL125 BLB125 WL20 VDD VSS bitcell_6t
XC20_126 BL126 BLB126 WL20 VDD VSS bitcell_6t
XC20_127 BL127 BLB127 WL20 VDD VSS bitcell_6t
XC21_0 BL0 BLB0 WL21 VDD VSS bitcell_6t
XC21_1 BL1 BLB1 WL21 VDD VSS bitcell_6t
XC21_2 BL2 BLB2 WL21 VDD VSS bitcell_6t
XC21_3 BL3 BLB3 WL21 VDD VSS bitcell_6t
XC21_4 BL4 BLB4 WL21 VDD VSS bitcell_6t
XC21_5 BL5 BLB5 WL21 VDD VSS bitcell_6t
XC21_6 BL6 BLB6 WL21 VDD VSS bitcell_6t
XC21_7 BL7 BLB7 WL21 VDD VSS bitcell_6t
XC21_8 BL8 BLB8 WL21 VDD VSS bitcell_6t
XC21_9 BL9 BLB9 WL21 VDD VSS bitcell_6t
XC21_10 BL10 BLB10 WL21 VDD VSS bitcell_6t
XC21_11 BL11 BLB11 WL21 VDD VSS bitcell_6t
XC21_12 BL12 BLB12 WL21 VDD VSS bitcell_6t
XC21_13 BL13 BLB13 WL21 VDD VSS bitcell_6t
XC21_14 BL14 BLB14 WL21 VDD VSS bitcell_6t
XC21_15 BL15 BLB15 WL21 VDD VSS bitcell_6t
XC21_16 BL16 BLB16 WL21 VDD VSS bitcell_6t
XC21_17 BL17 BLB17 WL21 VDD VSS bitcell_6t
XC21_18 BL18 BLB18 WL21 VDD VSS bitcell_6t
XC21_19 BL19 BLB19 WL21 VDD VSS bitcell_6t
XC21_20 BL20 BLB20 WL21 VDD VSS bitcell_6t
XC21_21 BL21 BLB21 WL21 VDD VSS bitcell_6t
XC21_22 BL22 BLB22 WL21 VDD VSS bitcell_6t
XC21_23 BL23 BLB23 WL21 VDD VSS bitcell_6t
XC21_24 BL24 BLB24 WL21 VDD VSS bitcell_6t
XC21_25 BL25 BLB25 WL21 VDD VSS bitcell_6t
XC21_26 BL26 BLB26 WL21 VDD VSS bitcell_6t
XC21_27 BL27 BLB27 WL21 VDD VSS bitcell_6t
XC21_28 BL28 BLB28 WL21 VDD VSS bitcell_6t
XC21_29 BL29 BLB29 WL21 VDD VSS bitcell_6t
XC21_30 BL30 BLB30 WL21 VDD VSS bitcell_6t
XC21_31 BL31 BLB31 WL21 VDD VSS bitcell_6t
XC21_32 BL32 BLB32 WL21 VDD VSS bitcell_6t
XC21_33 BL33 BLB33 WL21 VDD VSS bitcell_6t
XC21_34 BL34 BLB34 WL21 VDD VSS bitcell_6t
XC21_35 BL35 BLB35 WL21 VDD VSS bitcell_6t
XC21_36 BL36 BLB36 WL21 VDD VSS bitcell_6t
XC21_37 BL37 BLB37 WL21 VDD VSS bitcell_6t
XC21_38 BL38 BLB38 WL21 VDD VSS bitcell_6t
XC21_39 BL39 BLB39 WL21 VDD VSS bitcell_6t
XC21_40 BL40 BLB40 WL21 VDD VSS bitcell_6t
XC21_41 BL41 BLB41 WL21 VDD VSS bitcell_6t
XC21_42 BL42 BLB42 WL21 VDD VSS bitcell_6t
XC21_43 BL43 BLB43 WL21 VDD VSS bitcell_6t
XC21_44 BL44 BLB44 WL21 VDD VSS bitcell_6t
XC21_45 BL45 BLB45 WL21 VDD VSS bitcell_6t
XC21_46 BL46 BLB46 WL21 VDD VSS bitcell_6t
XC21_47 BL47 BLB47 WL21 VDD VSS bitcell_6t
XC21_48 BL48 BLB48 WL21 VDD VSS bitcell_6t
XC21_49 BL49 BLB49 WL21 VDD VSS bitcell_6t
XC21_50 BL50 BLB50 WL21 VDD VSS bitcell_6t
XC21_51 BL51 BLB51 WL21 VDD VSS bitcell_6t
XC21_52 BL52 BLB52 WL21 VDD VSS bitcell_6t
XC21_53 BL53 BLB53 WL21 VDD VSS bitcell_6t
XC21_54 BL54 BLB54 WL21 VDD VSS bitcell_6t
XC21_55 BL55 BLB55 WL21 VDD VSS bitcell_6t
XC21_56 BL56 BLB56 WL21 VDD VSS bitcell_6t
XC21_57 BL57 BLB57 WL21 VDD VSS bitcell_6t
XC21_58 BL58 BLB58 WL21 VDD VSS bitcell_6t
XC21_59 BL59 BLB59 WL21 VDD VSS bitcell_6t
XC21_60 BL60 BLB60 WL21 VDD VSS bitcell_6t
XC21_61 BL61 BLB61 WL21 VDD VSS bitcell_6t
XC21_62 BL62 BLB62 WL21 VDD VSS bitcell_6t
XC21_63 BL63 BLB63 WL21 VDD VSS bitcell_6t
XC21_64 BL64 BLB64 WL21 VDD VSS bitcell_6t
XC21_65 BL65 BLB65 WL21 VDD VSS bitcell_6t
XC21_66 BL66 BLB66 WL21 VDD VSS bitcell_6t
XC21_67 BL67 BLB67 WL21 VDD VSS bitcell_6t
XC21_68 BL68 BLB68 WL21 VDD VSS bitcell_6t
XC21_69 BL69 BLB69 WL21 VDD VSS bitcell_6t
XC21_70 BL70 BLB70 WL21 VDD VSS bitcell_6t
XC21_71 BL71 BLB71 WL21 VDD VSS bitcell_6t
XC21_72 BL72 BLB72 WL21 VDD VSS bitcell_6t
XC21_73 BL73 BLB73 WL21 VDD VSS bitcell_6t
XC21_74 BL74 BLB74 WL21 VDD VSS bitcell_6t
XC21_75 BL75 BLB75 WL21 VDD VSS bitcell_6t
XC21_76 BL76 BLB76 WL21 VDD VSS bitcell_6t
XC21_77 BL77 BLB77 WL21 VDD VSS bitcell_6t
XC21_78 BL78 BLB78 WL21 VDD VSS bitcell_6t
XC21_79 BL79 BLB79 WL21 VDD VSS bitcell_6t
XC21_80 BL80 BLB80 WL21 VDD VSS bitcell_6t
XC21_81 BL81 BLB81 WL21 VDD VSS bitcell_6t
XC21_82 BL82 BLB82 WL21 VDD VSS bitcell_6t
XC21_83 BL83 BLB83 WL21 VDD VSS bitcell_6t
XC21_84 BL84 BLB84 WL21 VDD VSS bitcell_6t
XC21_85 BL85 BLB85 WL21 VDD VSS bitcell_6t
XC21_86 BL86 BLB86 WL21 VDD VSS bitcell_6t
XC21_87 BL87 BLB87 WL21 VDD VSS bitcell_6t
XC21_88 BL88 BLB88 WL21 VDD VSS bitcell_6t
XC21_89 BL89 BLB89 WL21 VDD VSS bitcell_6t
XC21_90 BL90 BLB90 WL21 VDD VSS bitcell_6t
XC21_91 BL91 BLB91 WL21 VDD VSS bitcell_6t
XC21_92 BL92 BLB92 WL21 VDD VSS bitcell_6t
XC21_93 BL93 BLB93 WL21 VDD VSS bitcell_6t
XC21_94 BL94 BLB94 WL21 VDD VSS bitcell_6t
XC21_95 BL95 BLB95 WL21 VDD VSS bitcell_6t
XC21_96 BL96 BLB96 WL21 VDD VSS bitcell_6t
XC21_97 BL97 BLB97 WL21 VDD VSS bitcell_6t
XC21_98 BL98 BLB98 WL21 VDD VSS bitcell_6t
XC21_99 BL99 BLB99 WL21 VDD VSS bitcell_6t
XC21_100 BL100 BLB100 WL21 VDD VSS bitcell_6t
XC21_101 BL101 BLB101 WL21 VDD VSS bitcell_6t
XC21_102 BL102 BLB102 WL21 VDD VSS bitcell_6t
XC21_103 BL103 BLB103 WL21 VDD VSS bitcell_6t
XC21_104 BL104 BLB104 WL21 VDD VSS bitcell_6t
XC21_105 BL105 BLB105 WL21 VDD VSS bitcell_6t
XC21_106 BL106 BLB106 WL21 VDD VSS bitcell_6t
XC21_107 BL107 BLB107 WL21 VDD VSS bitcell_6t
XC21_108 BL108 BLB108 WL21 VDD VSS bitcell_6t
XC21_109 BL109 BLB109 WL21 VDD VSS bitcell_6t
XC21_110 BL110 BLB110 WL21 VDD VSS bitcell_6t
XC21_111 BL111 BLB111 WL21 VDD VSS bitcell_6t
XC21_112 BL112 BLB112 WL21 VDD VSS bitcell_6t
XC21_113 BL113 BLB113 WL21 VDD VSS bitcell_6t
XC21_114 BL114 BLB114 WL21 VDD VSS bitcell_6t
XC21_115 BL115 BLB115 WL21 VDD VSS bitcell_6t
XC21_116 BL116 BLB116 WL21 VDD VSS bitcell_6t
XC21_117 BL117 BLB117 WL21 VDD VSS bitcell_6t
XC21_118 BL118 BLB118 WL21 VDD VSS bitcell_6t
XC21_119 BL119 BLB119 WL21 VDD VSS bitcell_6t
XC21_120 BL120 BLB120 WL21 VDD VSS bitcell_6t
XC21_121 BL121 BLB121 WL21 VDD VSS bitcell_6t
XC21_122 BL122 BLB122 WL21 VDD VSS bitcell_6t
XC21_123 BL123 BLB123 WL21 VDD VSS bitcell_6t
XC21_124 BL124 BLB124 WL21 VDD VSS bitcell_6t
XC21_125 BL125 BLB125 WL21 VDD VSS bitcell_6t
XC21_126 BL126 BLB126 WL21 VDD VSS bitcell_6t
XC21_127 BL127 BLB127 WL21 VDD VSS bitcell_6t
XC22_0 BL0 BLB0 WL22 VDD VSS bitcell_6t
XC22_1 BL1 BLB1 WL22 VDD VSS bitcell_6t
XC22_2 BL2 BLB2 WL22 VDD VSS bitcell_6t
XC22_3 BL3 BLB3 WL22 VDD VSS bitcell_6t
XC22_4 BL4 BLB4 WL22 VDD VSS bitcell_6t
XC22_5 BL5 BLB5 WL22 VDD VSS bitcell_6t
XC22_6 BL6 BLB6 WL22 VDD VSS bitcell_6t
XC22_7 BL7 BLB7 WL22 VDD VSS bitcell_6t
XC22_8 BL8 BLB8 WL22 VDD VSS bitcell_6t
XC22_9 BL9 BLB9 WL22 VDD VSS bitcell_6t
XC22_10 BL10 BLB10 WL22 VDD VSS bitcell_6t
XC22_11 BL11 BLB11 WL22 VDD VSS bitcell_6t
XC22_12 BL12 BLB12 WL22 VDD VSS bitcell_6t
XC22_13 BL13 BLB13 WL22 VDD VSS bitcell_6t
XC22_14 BL14 BLB14 WL22 VDD VSS bitcell_6t
XC22_15 BL15 BLB15 WL22 VDD VSS bitcell_6t
XC22_16 BL16 BLB16 WL22 VDD VSS bitcell_6t
XC22_17 BL17 BLB17 WL22 VDD VSS bitcell_6t
XC22_18 BL18 BLB18 WL22 VDD VSS bitcell_6t
XC22_19 BL19 BLB19 WL22 VDD VSS bitcell_6t
XC22_20 BL20 BLB20 WL22 VDD VSS bitcell_6t
XC22_21 BL21 BLB21 WL22 VDD VSS bitcell_6t
XC22_22 BL22 BLB22 WL22 VDD VSS bitcell_6t
XC22_23 BL23 BLB23 WL22 VDD VSS bitcell_6t
XC22_24 BL24 BLB24 WL22 VDD VSS bitcell_6t
XC22_25 BL25 BLB25 WL22 VDD VSS bitcell_6t
XC22_26 BL26 BLB26 WL22 VDD VSS bitcell_6t
XC22_27 BL27 BLB27 WL22 VDD VSS bitcell_6t
XC22_28 BL28 BLB28 WL22 VDD VSS bitcell_6t
XC22_29 BL29 BLB29 WL22 VDD VSS bitcell_6t
XC22_30 BL30 BLB30 WL22 VDD VSS bitcell_6t
XC22_31 BL31 BLB31 WL22 VDD VSS bitcell_6t
XC22_32 BL32 BLB32 WL22 VDD VSS bitcell_6t
XC22_33 BL33 BLB33 WL22 VDD VSS bitcell_6t
XC22_34 BL34 BLB34 WL22 VDD VSS bitcell_6t
XC22_35 BL35 BLB35 WL22 VDD VSS bitcell_6t
XC22_36 BL36 BLB36 WL22 VDD VSS bitcell_6t
XC22_37 BL37 BLB37 WL22 VDD VSS bitcell_6t
XC22_38 BL38 BLB38 WL22 VDD VSS bitcell_6t
XC22_39 BL39 BLB39 WL22 VDD VSS bitcell_6t
XC22_40 BL40 BLB40 WL22 VDD VSS bitcell_6t
XC22_41 BL41 BLB41 WL22 VDD VSS bitcell_6t
XC22_42 BL42 BLB42 WL22 VDD VSS bitcell_6t
XC22_43 BL43 BLB43 WL22 VDD VSS bitcell_6t
XC22_44 BL44 BLB44 WL22 VDD VSS bitcell_6t
XC22_45 BL45 BLB45 WL22 VDD VSS bitcell_6t
XC22_46 BL46 BLB46 WL22 VDD VSS bitcell_6t
XC22_47 BL47 BLB47 WL22 VDD VSS bitcell_6t
XC22_48 BL48 BLB48 WL22 VDD VSS bitcell_6t
XC22_49 BL49 BLB49 WL22 VDD VSS bitcell_6t
XC22_50 BL50 BLB50 WL22 VDD VSS bitcell_6t
XC22_51 BL51 BLB51 WL22 VDD VSS bitcell_6t
XC22_52 BL52 BLB52 WL22 VDD VSS bitcell_6t
XC22_53 BL53 BLB53 WL22 VDD VSS bitcell_6t
XC22_54 BL54 BLB54 WL22 VDD VSS bitcell_6t
XC22_55 BL55 BLB55 WL22 VDD VSS bitcell_6t
XC22_56 BL56 BLB56 WL22 VDD VSS bitcell_6t
XC22_57 BL57 BLB57 WL22 VDD VSS bitcell_6t
XC22_58 BL58 BLB58 WL22 VDD VSS bitcell_6t
XC22_59 BL59 BLB59 WL22 VDD VSS bitcell_6t
XC22_60 BL60 BLB60 WL22 VDD VSS bitcell_6t
XC22_61 BL61 BLB61 WL22 VDD VSS bitcell_6t
XC22_62 BL62 BLB62 WL22 VDD VSS bitcell_6t
XC22_63 BL63 BLB63 WL22 VDD VSS bitcell_6t
XC22_64 BL64 BLB64 WL22 VDD VSS bitcell_6t
XC22_65 BL65 BLB65 WL22 VDD VSS bitcell_6t
XC22_66 BL66 BLB66 WL22 VDD VSS bitcell_6t
XC22_67 BL67 BLB67 WL22 VDD VSS bitcell_6t
XC22_68 BL68 BLB68 WL22 VDD VSS bitcell_6t
XC22_69 BL69 BLB69 WL22 VDD VSS bitcell_6t
XC22_70 BL70 BLB70 WL22 VDD VSS bitcell_6t
XC22_71 BL71 BLB71 WL22 VDD VSS bitcell_6t
XC22_72 BL72 BLB72 WL22 VDD VSS bitcell_6t
XC22_73 BL73 BLB73 WL22 VDD VSS bitcell_6t
XC22_74 BL74 BLB74 WL22 VDD VSS bitcell_6t
XC22_75 BL75 BLB75 WL22 VDD VSS bitcell_6t
XC22_76 BL76 BLB76 WL22 VDD VSS bitcell_6t
XC22_77 BL77 BLB77 WL22 VDD VSS bitcell_6t
XC22_78 BL78 BLB78 WL22 VDD VSS bitcell_6t
XC22_79 BL79 BLB79 WL22 VDD VSS bitcell_6t
XC22_80 BL80 BLB80 WL22 VDD VSS bitcell_6t
XC22_81 BL81 BLB81 WL22 VDD VSS bitcell_6t
XC22_82 BL82 BLB82 WL22 VDD VSS bitcell_6t
XC22_83 BL83 BLB83 WL22 VDD VSS bitcell_6t
XC22_84 BL84 BLB84 WL22 VDD VSS bitcell_6t
XC22_85 BL85 BLB85 WL22 VDD VSS bitcell_6t
XC22_86 BL86 BLB86 WL22 VDD VSS bitcell_6t
XC22_87 BL87 BLB87 WL22 VDD VSS bitcell_6t
XC22_88 BL88 BLB88 WL22 VDD VSS bitcell_6t
XC22_89 BL89 BLB89 WL22 VDD VSS bitcell_6t
XC22_90 BL90 BLB90 WL22 VDD VSS bitcell_6t
XC22_91 BL91 BLB91 WL22 VDD VSS bitcell_6t
XC22_92 BL92 BLB92 WL22 VDD VSS bitcell_6t
XC22_93 BL93 BLB93 WL22 VDD VSS bitcell_6t
XC22_94 BL94 BLB94 WL22 VDD VSS bitcell_6t
XC22_95 BL95 BLB95 WL22 VDD VSS bitcell_6t
XC22_96 BL96 BLB96 WL22 VDD VSS bitcell_6t
XC22_97 BL97 BLB97 WL22 VDD VSS bitcell_6t
XC22_98 BL98 BLB98 WL22 VDD VSS bitcell_6t
XC22_99 BL99 BLB99 WL22 VDD VSS bitcell_6t
XC22_100 BL100 BLB100 WL22 VDD VSS bitcell_6t
XC22_101 BL101 BLB101 WL22 VDD VSS bitcell_6t
XC22_102 BL102 BLB102 WL22 VDD VSS bitcell_6t
XC22_103 BL103 BLB103 WL22 VDD VSS bitcell_6t
XC22_104 BL104 BLB104 WL22 VDD VSS bitcell_6t
XC22_105 BL105 BLB105 WL22 VDD VSS bitcell_6t
XC22_106 BL106 BLB106 WL22 VDD VSS bitcell_6t
XC22_107 BL107 BLB107 WL22 VDD VSS bitcell_6t
XC22_108 BL108 BLB108 WL22 VDD VSS bitcell_6t
XC22_109 BL109 BLB109 WL22 VDD VSS bitcell_6t
XC22_110 BL110 BLB110 WL22 VDD VSS bitcell_6t
XC22_111 BL111 BLB111 WL22 VDD VSS bitcell_6t
XC22_112 BL112 BLB112 WL22 VDD VSS bitcell_6t
XC22_113 BL113 BLB113 WL22 VDD VSS bitcell_6t
XC22_114 BL114 BLB114 WL22 VDD VSS bitcell_6t
XC22_115 BL115 BLB115 WL22 VDD VSS bitcell_6t
XC22_116 BL116 BLB116 WL22 VDD VSS bitcell_6t
XC22_117 BL117 BLB117 WL22 VDD VSS bitcell_6t
XC22_118 BL118 BLB118 WL22 VDD VSS bitcell_6t
XC22_119 BL119 BLB119 WL22 VDD VSS bitcell_6t
XC22_120 BL120 BLB120 WL22 VDD VSS bitcell_6t
XC22_121 BL121 BLB121 WL22 VDD VSS bitcell_6t
XC22_122 BL122 BLB122 WL22 VDD VSS bitcell_6t
XC22_123 BL123 BLB123 WL22 VDD VSS bitcell_6t
XC22_124 BL124 BLB124 WL22 VDD VSS bitcell_6t
XC22_125 BL125 BLB125 WL22 VDD VSS bitcell_6t
XC22_126 BL126 BLB126 WL22 VDD VSS bitcell_6t
XC22_127 BL127 BLB127 WL22 VDD VSS bitcell_6t
XC23_0 BL0 BLB0 WL23 VDD VSS bitcell_6t
XC23_1 BL1 BLB1 WL23 VDD VSS bitcell_6t
XC23_2 BL2 BLB2 WL23 VDD VSS bitcell_6t
XC23_3 BL3 BLB3 WL23 VDD VSS bitcell_6t
XC23_4 BL4 BLB4 WL23 VDD VSS bitcell_6t
XC23_5 BL5 BLB5 WL23 VDD VSS bitcell_6t
XC23_6 BL6 BLB6 WL23 VDD VSS bitcell_6t
XC23_7 BL7 BLB7 WL23 VDD VSS bitcell_6t
XC23_8 BL8 BLB8 WL23 VDD VSS bitcell_6t
XC23_9 BL9 BLB9 WL23 VDD VSS bitcell_6t
XC23_10 BL10 BLB10 WL23 VDD VSS bitcell_6t
XC23_11 BL11 BLB11 WL23 VDD VSS bitcell_6t
XC23_12 BL12 BLB12 WL23 VDD VSS bitcell_6t
XC23_13 BL13 BLB13 WL23 VDD VSS bitcell_6t
XC23_14 BL14 BLB14 WL23 VDD VSS bitcell_6t
XC23_15 BL15 BLB15 WL23 VDD VSS bitcell_6t
XC23_16 BL16 BLB16 WL23 VDD VSS bitcell_6t
XC23_17 BL17 BLB17 WL23 VDD VSS bitcell_6t
XC23_18 BL18 BLB18 WL23 VDD VSS bitcell_6t
XC23_19 BL19 BLB19 WL23 VDD VSS bitcell_6t
XC23_20 BL20 BLB20 WL23 VDD VSS bitcell_6t
XC23_21 BL21 BLB21 WL23 VDD VSS bitcell_6t
XC23_22 BL22 BLB22 WL23 VDD VSS bitcell_6t
XC23_23 BL23 BLB23 WL23 VDD VSS bitcell_6t
XC23_24 BL24 BLB24 WL23 VDD VSS bitcell_6t
XC23_25 BL25 BLB25 WL23 VDD VSS bitcell_6t
XC23_26 BL26 BLB26 WL23 VDD VSS bitcell_6t
XC23_27 BL27 BLB27 WL23 VDD VSS bitcell_6t
XC23_28 BL28 BLB28 WL23 VDD VSS bitcell_6t
XC23_29 BL29 BLB29 WL23 VDD VSS bitcell_6t
XC23_30 BL30 BLB30 WL23 VDD VSS bitcell_6t
XC23_31 BL31 BLB31 WL23 VDD VSS bitcell_6t
XC23_32 BL32 BLB32 WL23 VDD VSS bitcell_6t
XC23_33 BL33 BLB33 WL23 VDD VSS bitcell_6t
XC23_34 BL34 BLB34 WL23 VDD VSS bitcell_6t
XC23_35 BL35 BLB35 WL23 VDD VSS bitcell_6t
XC23_36 BL36 BLB36 WL23 VDD VSS bitcell_6t
XC23_37 BL37 BLB37 WL23 VDD VSS bitcell_6t
XC23_38 BL38 BLB38 WL23 VDD VSS bitcell_6t
XC23_39 BL39 BLB39 WL23 VDD VSS bitcell_6t
XC23_40 BL40 BLB40 WL23 VDD VSS bitcell_6t
XC23_41 BL41 BLB41 WL23 VDD VSS bitcell_6t
XC23_42 BL42 BLB42 WL23 VDD VSS bitcell_6t
XC23_43 BL43 BLB43 WL23 VDD VSS bitcell_6t
XC23_44 BL44 BLB44 WL23 VDD VSS bitcell_6t
XC23_45 BL45 BLB45 WL23 VDD VSS bitcell_6t
XC23_46 BL46 BLB46 WL23 VDD VSS bitcell_6t
XC23_47 BL47 BLB47 WL23 VDD VSS bitcell_6t
XC23_48 BL48 BLB48 WL23 VDD VSS bitcell_6t
XC23_49 BL49 BLB49 WL23 VDD VSS bitcell_6t
XC23_50 BL50 BLB50 WL23 VDD VSS bitcell_6t
XC23_51 BL51 BLB51 WL23 VDD VSS bitcell_6t
XC23_52 BL52 BLB52 WL23 VDD VSS bitcell_6t
XC23_53 BL53 BLB53 WL23 VDD VSS bitcell_6t
XC23_54 BL54 BLB54 WL23 VDD VSS bitcell_6t
XC23_55 BL55 BLB55 WL23 VDD VSS bitcell_6t
XC23_56 BL56 BLB56 WL23 VDD VSS bitcell_6t
XC23_57 BL57 BLB57 WL23 VDD VSS bitcell_6t
XC23_58 BL58 BLB58 WL23 VDD VSS bitcell_6t
XC23_59 BL59 BLB59 WL23 VDD VSS bitcell_6t
XC23_60 BL60 BLB60 WL23 VDD VSS bitcell_6t
XC23_61 BL61 BLB61 WL23 VDD VSS bitcell_6t
XC23_62 BL62 BLB62 WL23 VDD VSS bitcell_6t
XC23_63 BL63 BLB63 WL23 VDD VSS bitcell_6t
XC23_64 BL64 BLB64 WL23 VDD VSS bitcell_6t
XC23_65 BL65 BLB65 WL23 VDD VSS bitcell_6t
XC23_66 BL66 BLB66 WL23 VDD VSS bitcell_6t
XC23_67 BL67 BLB67 WL23 VDD VSS bitcell_6t
XC23_68 BL68 BLB68 WL23 VDD VSS bitcell_6t
XC23_69 BL69 BLB69 WL23 VDD VSS bitcell_6t
XC23_70 BL70 BLB70 WL23 VDD VSS bitcell_6t
XC23_71 BL71 BLB71 WL23 VDD VSS bitcell_6t
XC23_72 BL72 BLB72 WL23 VDD VSS bitcell_6t
XC23_73 BL73 BLB73 WL23 VDD VSS bitcell_6t
XC23_74 BL74 BLB74 WL23 VDD VSS bitcell_6t
XC23_75 BL75 BLB75 WL23 VDD VSS bitcell_6t
XC23_76 BL76 BLB76 WL23 VDD VSS bitcell_6t
XC23_77 BL77 BLB77 WL23 VDD VSS bitcell_6t
XC23_78 BL78 BLB78 WL23 VDD VSS bitcell_6t
XC23_79 BL79 BLB79 WL23 VDD VSS bitcell_6t
XC23_80 BL80 BLB80 WL23 VDD VSS bitcell_6t
XC23_81 BL81 BLB81 WL23 VDD VSS bitcell_6t
XC23_82 BL82 BLB82 WL23 VDD VSS bitcell_6t
XC23_83 BL83 BLB83 WL23 VDD VSS bitcell_6t
XC23_84 BL84 BLB84 WL23 VDD VSS bitcell_6t
XC23_85 BL85 BLB85 WL23 VDD VSS bitcell_6t
XC23_86 BL86 BLB86 WL23 VDD VSS bitcell_6t
XC23_87 BL87 BLB87 WL23 VDD VSS bitcell_6t
XC23_88 BL88 BLB88 WL23 VDD VSS bitcell_6t
XC23_89 BL89 BLB89 WL23 VDD VSS bitcell_6t
XC23_90 BL90 BLB90 WL23 VDD VSS bitcell_6t
XC23_91 BL91 BLB91 WL23 VDD VSS bitcell_6t
XC23_92 BL92 BLB92 WL23 VDD VSS bitcell_6t
XC23_93 BL93 BLB93 WL23 VDD VSS bitcell_6t
XC23_94 BL94 BLB94 WL23 VDD VSS bitcell_6t
XC23_95 BL95 BLB95 WL23 VDD VSS bitcell_6t
XC23_96 BL96 BLB96 WL23 VDD VSS bitcell_6t
XC23_97 BL97 BLB97 WL23 VDD VSS bitcell_6t
XC23_98 BL98 BLB98 WL23 VDD VSS bitcell_6t
XC23_99 BL99 BLB99 WL23 VDD VSS bitcell_6t
XC23_100 BL100 BLB100 WL23 VDD VSS bitcell_6t
XC23_101 BL101 BLB101 WL23 VDD VSS bitcell_6t
XC23_102 BL102 BLB102 WL23 VDD VSS bitcell_6t
XC23_103 BL103 BLB103 WL23 VDD VSS bitcell_6t
XC23_104 BL104 BLB104 WL23 VDD VSS bitcell_6t
XC23_105 BL105 BLB105 WL23 VDD VSS bitcell_6t
XC23_106 BL106 BLB106 WL23 VDD VSS bitcell_6t
XC23_107 BL107 BLB107 WL23 VDD VSS bitcell_6t
XC23_108 BL108 BLB108 WL23 VDD VSS bitcell_6t
XC23_109 BL109 BLB109 WL23 VDD VSS bitcell_6t
XC23_110 BL110 BLB110 WL23 VDD VSS bitcell_6t
XC23_111 BL111 BLB111 WL23 VDD VSS bitcell_6t
XC23_112 BL112 BLB112 WL23 VDD VSS bitcell_6t
XC23_113 BL113 BLB113 WL23 VDD VSS bitcell_6t
XC23_114 BL114 BLB114 WL23 VDD VSS bitcell_6t
XC23_115 BL115 BLB115 WL23 VDD VSS bitcell_6t
XC23_116 BL116 BLB116 WL23 VDD VSS bitcell_6t
XC23_117 BL117 BLB117 WL23 VDD VSS bitcell_6t
XC23_118 BL118 BLB118 WL23 VDD VSS bitcell_6t
XC23_119 BL119 BLB119 WL23 VDD VSS bitcell_6t
XC23_120 BL120 BLB120 WL23 VDD VSS bitcell_6t
XC23_121 BL121 BLB121 WL23 VDD VSS bitcell_6t
XC23_122 BL122 BLB122 WL23 VDD VSS bitcell_6t
XC23_123 BL123 BLB123 WL23 VDD VSS bitcell_6t
XC23_124 BL124 BLB124 WL23 VDD VSS bitcell_6t
XC23_125 BL125 BLB125 WL23 VDD VSS bitcell_6t
XC23_126 BL126 BLB126 WL23 VDD VSS bitcell_6t
XC23_127 BL127 BLB127 WL23 VDD VSS bitcell_6t
XC24_0 BL0 BLB0 WL24 VDD VSS bitcell_6t
XC24_1 BL1 BLB1 WL24 VDD VSS bitcell_6t
XC24_2 BL2 BLB2 WL24 VDD VSS bitcell_6t
XC24_3 BL3 BLB3 WL24 VDD VSS bitcell_6t
XC24_4 BL4 BLB4 WL24 VDD VSS bitcell_6t
XC24_5 BL5 BLB5 WL24 VDD VSS bitcell_6t
XC24_6 BL6 BLB6 WL24 VDD VSS bitcell_6t
XC24_7 BL7 BLB7 WL24 VDD VSS bitcell_6t
XC24_8 BL8 BLB8 WL24 VDD VSS bitcell_6t
XC24_9 BL9 BLB9 WL24 VDD VSS bitcell_6t
XC24_10 BL10 BLB10 WL24 VDD VSS bitcell_6t
XC24_11 BL11 BLB11 WL24 VDD VSS bitcell_6t
XC24_12 BL12 BLB12 WL24 VDD VSS bitcell_6t
XC24_13 BL13 BLB13 WL24 VDD VSS bitcell_6t
XC24_14 BL14 BLB14 WL24 VDD VSS bitcell_6t
XC24_15 BL15 BLB15 WL24 VDD VSS bitcell_6t
XC24_16 BL16 BLB16 WL24 VDD VSS bitcell_6t
XC24_17 BL17 BLB17 WL24 VDD VSS bitcell_6t
XC24_18 BL18 BLB18 WL24 VDD VSS bitcell_6t
XC24_19 BL19 BLB19 WL24 VDD VSS bitcell_6t
XC24_20 BL20 BLB20 WL24 VDD VSS bitcell_6t
XC24_21 BL21 BLB21 WL24 VDD VSS bitcell_6t
XC24_22 BL22 BLB22 WL24 VDD VSS bitcell_6t
XC24_23 BL23 BLB23 WL24 VDD VSS bitcell_6t
XC24_24 BL24 BLB24 WL24 VDD VSS bitcell_6t
XC24_25 BL25 BLB25 WL24 VDD VSS bitcell_6t
XC24_26 BL26 BLB26 WL24 VDD VSS bitcell_6t
XC24_27 BL27 BLB27 WL24 VDD VSS bitcell_6t
XC24_28 BL28 BLB28 WL24 VDD VSS bitcell_6t
XC24_29 BL29 BLB29 WL24 VDD VSS bitcell_6t
XC24_30 BL30 BLB30 WL24 VDD VSS bitcell_6t
XC24_31 BL31 BLB31 WL24 VDD VSS bitcell_6t
XC24_32 BL32 BLB32 WL24 VDD VSS bitcell_6t
XC24_33 BL33 BLB33 WL24 VDD VSS bitcell_6t
XC24_34 BL34 BLB34 WL24 VDD VSS bitcell_6t
XC24_35 BL35 BLB35 WL24 VDD VSS bitcell_6t
XC24_36 BL36 BLB36 WL24 VDD VSS bitcell_6t
XC24_37 BL37 BLB37 WL24 VDD VSS bitcell_6t
XC24_38 BL38 BLB38 WL24 VDD VSS bitcell_6t
XC24_39 BL39 BLB39 WL24 VDD VSS bitcell_6t
XC24_40 BL40 BLB40 WL24 VDD VSS bitcell_6t
XC24_41 BL41 BLB41 WL24 VDD VSS bitcell_6t
XC24_42 BL42 BLB42 WL24 VDD VSS bitcell_6t
XC24_43 BL43 BLB43 WL24 VDD VSS bitcell_6t
XC24_44 BL44 BLB44 WL24 VDD VSS bitcell_6t
XC24_45 BL45 BLB45 WL24 VDD VSS bitcell_6t
XC24_46 BL46 BLB46 WL24 VDD VSS bitcell_6t
XC24_47 BL47 BLB47 WL24 VDD VSS bitcell_6t
XC24_48 BL48 BLB48 WL24 VDD VSS bitcell_6t
XC24_49 BL49 BLB49 WL24 VDD VSS bitcell_6t
XC24_50 BL50 BLB50 WL24 VDD VSS bitcell_6t
XC24_51 BL51 BLB51 WL24 VDD VSS bitcell_6t
XC24_52 BL52 BLB52 WL24 VDD VSS bitcell_6t
XC24_53 BL53 BLB53 WL24 VDD VSS bitcell_6t
XC24_54 BL54 BLB54 WL24 VDD VSS bitcell_6t
XC24_55 BL55 BLB55 WL24 VDD VSS bitcell_6t
XC24_56 BL56 BLB56 WL24 VDD VSS bitcell_6t
XC24_57 BL57 BLB57 WL24 VDD VSS bitcell_6t
XC24_58 BL58 BLB58 WL24 VDD VSS bitcell_6t
XC24_59 BL59 BLB59 WL24 VDD VSS bitcell_6t
XC24_60 BL60 BLB60 WL24 VDD VSS bitcell_6t
XC24_61 BL61 BLB61 WL24 VDD VSS bitcell_6t
XC24_62 BL62 BLB62 WL24 VDD VSS bitcell_6t
XC24_63 BL63 BLB63 WL24 VDD VSS bitcell_6t
XC24_64 BL64 BLB64 WL24 VDD VSS bitcell_6t
XC24_65 BL65 BLB65 WL24 VDD VSS bitcell_6t
XC24_66 BL66 BLB66 WL24 VDD VSS bitcell_6t
XC24_67 BL67 BLB67 WL24 VDD VSS bitcell_6t
XC24_68 BL68 BLB68 WL24 VDD VSS bitcell_6t
XC24_69 BL69 BLB69 WL24 VDD VSS bitcell_6t
XC24_70 BL70 BLB70 WL24 VDD VSS bitcell_6t
XC24_71 BL71 BLB71 WL24 VDD VSS bitcell_6t
XC24_72 BL72 BLB72 WL24 VDD VSS bitcell_6t
XC24_73 BL73 BLB73 WL24 VDD VSS bitcell_6t
XC24_74 BL74 BLB74 WL24 VDD VSS bitcell_6t
XC24_75 BL75 BLB75 WL24 VDD VSS bitcell_6t
XC24_76 BL76 BLB76 WL24 VDD VSS bitcell_6t
XC24_77 BL77 BLB77 WL24 VDD VSS bitcell_6t
XC24_78 BL78 BLB78 WL24 VDD VSS bitcell_6t
XC24_79 BL79 BLB79 WL24 VDD VSS bitcell_6t
XC24_80 BL80 BLB80 WL24 VDD VSS bitcell_6t
XC24_81 BL81 BLB81 WL24 VDD VSS bitcell_6t
XC24_82 BL82 BLB82 WL24 VDD VSS bitcell_6t
XC24_83 BL83 BLB83 WL24 VDD VSS bitcell_6t
XC24_84 BL84 BLB84 WL24 VDD VSS bitcell_6t
XC24_85 BL85 BLB85 WL24 VDD VSS bitcell_6t
XC24_86 BL86 BLB86 WL24 VDD VSS bitcell_6t
XC24_87 BL87 BLB87 WL24 VDD VSS bitcell_6t
XC24_88 BL88 BLB88 WL24 VDD VSS bitcell_6t
XC24_89 BL89 BLB89 WL24 VDD VSS bitcell_6t
XC24_90 BL90 BLB90 WL24 VDD VSS bitcell_6t
XC24_91 BL91 BLB91 WL24 VDD VSS bitcell_6t
XC24_92 BL92 BLB92 WL24 VDD VSS bitcell_6t
XC24_93 BL93 BLB93 WL24 VDD VSS bitcell_6t
XC24_94 BL94 BLB94 WL24 VDD VSS bitcell_6t
XC24_95 BL95 BLB95 WL24 VDD VSS bitcell_6t
XC24_96 BL96 BLB96 WL24 VDD VSS bitcell_6t
XC24_97 BL97 BLB97 WL24 VDD VSS bitcell_6t
XC24_98 BL98 BLB98 WL24 VDD VSS bitcell_6t
XC24_99 BL99 BLB99 WL24 VDD VSS bitcell_6t
XC24_100 BL100 BLB100 WL24 VDD VSS bitcell_6t
XC24_101 BL101 BLB101 WL24 VDD VSS bitcell_6t
XC24_102 BL102 BLB102 WL24 VDD VSS bitcell_6t
XC24_103 BL103 BLB103 WL24 VDD VSS bitcell_6t
XC24_104 BL104 BLB104 WL24 VDD VSS bitcell_6t
XC24_105 BL105 BLB105 WL24 VDD VSS bitcell_6t
XC24_106 BL106 BLB106 WL24 VDD VSS bitcell_6t
XC24_107 BL107 BLB107 WL24 VDD VSS bitcell_6t
XC24_108 BL108 BLB108 WL24 VDD VSS bitcell_6t
XC24_109 BL109 BLB109 WL24 VDD VSS bitcell_6t
XC24_110 BL110 BLB110 WL24 VDD VSS bitcell_6t
XC24_111 BL111 BLB111 WL24 VDD VSS bitcell_6t
XC24_112 BL112 BLB112 WL24 VDD VSS bitcell_6t
XC24_113 BL113 BLB113 WL24 VDD VSS bitcell_6t
XC24_114 BL114 BLB114 WL24 VDD VSS bitcell_6t
XC24_115 BL115 BLB115 WL24 VDD VSS bitcell_6t
XC24_116 BL116 BLB116 WL24 VDD VSS bitcell_6t
XC24_117 BL117 BLB117 WL24 VDD VSS bitcell_6t
XC24_118 BL118 BLB118 WL24 VDD VSS bitcell_6t
XC24_119 BL119 BLB119 WL24 VDD VSS bitcell_6t
XC24_120 BL120 BLB120 WL24 VDD VSS bitcell_6t
XC24_121 BL121 BLB121 WL24 VDD VSS bitcell_6t
XC24_122 BL122 BLB122 WL24 VDD VSS bitcell_6t
XC24_123 BL123 BLB123 WL24 VDD VSS bitcell_6t
XC24_124 BL124 BLB124 WL24 VDD VSS bitcell_6t
XC24_125 BL125 BLB125 WL24 VDD VSS bitcell_6t
XC24_126 BL126 BLB126 WL24 VDD VSS bitcell_6t
XC24_127 BL127 BLB127 WL24 VDD VSS bitcell_6t
XC25_0 BL0 BLB0 WL25 VDD VSS bitcell_6t
XC25_1 BL1 BLB1 WL25 VDD VSS bitcell_6t
XC25_2 BL2 BLB2 WL25 VDD VSS bitcell_6t
XC25_3 BL3 BLB3 WL25 VDD VSS bitcell_6t
XC25_4 BL4 BLB4 WL25 VDD VSS bitcell_6t
XC25_5 BL5 BLB5 WL25 VDD VSS bitcell_6t
XC25_6 BL6 BLB6 WL25 VDD VSS bitcell_6t
XC25_7 BL7 BLB7 WL25 VDD VSS bitcell_6t
XC25_8 BL8 BLB8 WL25 VDD VSS bitcell_6t
XC25_9 BL9 BLB9 WL25 VDD VSS bitcell_6t
XC25_10 BL10 BLB10 WL25 VDD VSS bitcell_6t
XC25_11 BL11 BLB11 WL25 VDD VSS bitcell_6t
XC25_12 BL12 BLB12 WL25 VDD VSS bitcell_6t
XC25_13 BL13 BLB13 WL25 VDD VSS bitcell_6t
XC25_14 BL14 BLB14 WL25 VDD VSS bitcell_6t
XC25_15 BL15 BLB15 WL25 VDD VSS bitcell_6t
XC25_16 BL16 BLB16 WL25 VDD VSS bitcell_6t
XC25_17 BL17 BLB17 WL25 VDD VSS bitcell_6t
XC25_18 BL18 BLB18 WL25 VDD VSS bitcell_6t
XC25_19 BL19 BLB19 WL25 VDD VSS bitcell_6t
XC25_20 BL20 BLB20 WL25 VDD VSS bitcell_6t
XC25_21 BL21 BLB21 WL25 VDD VSS bitcell_6t
XC25_22 BL22 BLB22 WL25 VDD VSS bitcell_6t
XC25_23 BL23 BLB23 WL25 VDD VSS bitcell_6t
XC25_24 BL24 BLB24 WL25 VDD VSS bitcell_6t
XC25_25 BL25 BLB25 WL25 VDD VSS bitcell_6t
XC25_26 BL26 BLB26 WL25 VDD VSS bitcell_6t
XC25_27 BL27 BLB27 WL25 VDD VSS bitcell_6t
XC25_28 BL28 BLB28 WL25 VDD VSS bitcell_6t
XC25_29 BL29 BLB29 WL25 VDD VSS bitcell_6t
XC25_30 BL30 BLB30 WL25 VDD VSS bitcell_6t
XC25_31 BL31 BLB31 WL25 VDD VSS bitcell_6t
XC25_32 BL32 BLB32 WL25 VDD VSS bitcell_6t
XC25_33 BL33 BLB33 WL25 VDD VSS bitcell_6t
XC25_34 BL34 BLB34 WL25 VDD VSS bitcell_6t
XC25_35 BL35 BLB35 WL25 VDD VSS bitcell_6t
XC25_36 BL36 BLB36 WL25 VDD VSS bitcell_6t
XC25_37 BL37 BLB37 WL25 VDD VSS bitcell_6t
XC25_38 BL38 BLB38 WL25 VDD VSS bitcell_6t
XC25_39 BL39 BLB39 WL25 VDD VSS bitcell_6t
XC25_40 BL40 BLB40 WL25 VDD VSS bitcell_6t
XC25_41 BL41 BLB41 WL25 VDD VSS bitcell_6t
XC25_42 BL42 BLB42 WL25 VDD VSS bitcell_6t
XC25_43 BL43 BLB43 WL25 VDD VSS bitcell_6t
XC25_44 BL44 BLB44 WL25 VDD VSS bitcell_6t
XC25_45 BL45 BLB45 WL25 VDD VSS bitcell_6t
XC25_46 BL46 BLB46 WL25 VDD VSS bitcell_6t
XC25_47 BL47 BLB47 WL25 VDD VSS bitcell_6t
XC25_48 BL48 BLB48 WL25 VDD VSS bitcell_6t
XC25_49 BL49 BLB49 WL25 VDD VSS bitcell_6t
XC25_50 BL50 BLB50 WL25 VDD VSS bitcell_6t
XC25_51 BL51 BLB51 WL25 VDD VSS bitcell_6t
XC25_52 BL52 BLB52 WL25 VDD VSS bitcell_6t
XC25_53 BL53 BLB53 WL25 VDD VSS bitcell_6t
XC25_54 BL54 BLB54 WL25 VDD VSS bitcell_6t
XC25_55 BL55 BLB55 WL25 VDD VSS bitcell_6t
XC25_56 BL56 BLB56 WL25 VDD VSS bitcell_6t
XC25_57 BL57 BLB57 WL25 VDD VSS bitcell_6t
XC25_58 BL58 BLB58 WL25 VDD VSS bitcell_6t
XC25_59 BL59 BLB59 WL25 VDD VSS bitcell_6t
XC25_60 BL60 BLB60 WL25 VDD VSS bitcell_6t
XC25_61 BL61 BLB61 WL25 VDD VSS bitcell_6t
XC25_62 BL62 BLB62 WL25 VDD VSS bitcell_6t
XC25_63 BL63 BLB63 WL25 VDD VSS bitcell_6t
XC25_64 BL64 BLB64 WL25 VDD VSS bitcell_6t
XC25_65 BL65 BLB65 WL25 VDD VSS bitcell_6t
XC25_66 BL66 BLB66 WL25 VDD VSS bitcell_6t
XC25_67 BL67 BLB67 WL25 VDD VSS bitcell_6t
XC25_68 BL68 BLB68 WL25 VDD VSS bitcell_6t
XC25_69 BL69 BLB69 WL25 VDD VSS bitcell_6t
XC25_70 BL70 BLB70 WL25 VDD VSS bitcell_6t
XC25_71 BL71 BLB71 WL25 VDD VSS bitcell_6t
XC25_72 BL72 BLB72 WL25 VDD VSS bitcell_6t
XC25_73 BL73 BLB73 WL25 VDD VSS bitcell_6t
XC25_74 BL74 BLB74 WL25 VDD VSS bitcell_6t
XC25_75 BL75 BLB75 WL25 VDD VSS bitcell_6t
XC25_76 BL76 BLB76 WL25 VDD VSS bitcell_6t
XC25_77 BL77 BLB77 WL25 VDD VSS bitcell_6t
XC25_78 BL78 BLB78 WL25 VDD VSS bitcell_6t
XC25_79 BL79 BLB79 WL25 VDD VSS bitcell_6t
XC25_80 BL80 BLB80 WL25 VDD VSS bitcell_6t
XC25_81 BL81 BLB81 WL25 VDD VSS bitcell_6t
XC25_82 BL82 BLB82 WL25 VDD VSS bitcell_6t
XC25_83 BL83 BLB83 WL25 VDD VSS bitcell_6t
XC25_84 BL84 BLB84 WL25 VDD VSS bitcell_6t
XC25_85 BL85 BLB85 WL25 VDD VSS bitcell_6t
XC25_86 BL86 BLB86 WL25 VDD VSS bitcell_6t
XC25_87 BL87 BLB87 WL25 VDD VSS bitcell_6t
XC25_88 BL88 BLB88 WL25 VDD VSS bitcell_6t
XC25_89 BL89 BLB89 WL25 VDD VSS bitcell_6t
XC25_90 BL90 BLB90 WL25 VDD VSS bitcell_6t
XC25_91 BL91 BLB91 WL25 VDD VSS bitcell_6t
XC25_92 BL92 BLB92 WL25 VDD VSS bitcell_6t
XC25_93 BL93 BLB93 WL25 VDD VSS bitcell_6t
XC25_94 BL94 BLB94 WL25 VDD VSS bitcell_6t
XC25_95 BL95 BLB95 WL25 VDD VSS bitcell_6t
XC25_96 BL96 BLB96 WL25 VDD VSS bitcell_6t
XC25_97 BL97 BLB97 WL25 VDD VSS bitcell_6t
XC25_98 BL98 BLB98 WL25 VDD VSS bitcell_6t
XC25_99 BL99 BLB99 WL25 VDD VSS bitcell_6t
XC25_100 BL100 BLB100 WL25 VDD VSS bitcell_6t
XC25_101 BL101 BLB101 WL25 VDD VSS bitcell_6t
XC25_102 BL102 BLB102 WL25 VDD VSS bitcell_6t
XC25_103 BL103 BLB103 WL25 VDD VSS bitcell_6t
XC25_104 BL104 BLB104 WL25 VDD VSS bitcell_6t
XC25_105 BL105 BLB105 WL25 VDD VSS bitcell_6t
XC25_106 BL106 BLB106 WL25 VDD VSS bitcell_6t
XC25_107 BL107 BLB107 WL25 VDD VSS bitcell_6t
XC25_108 BL108 BLB108 WL25 VDD VSS bitcell_6t
XC25_109 BL109 BLB109 WL25 VDD VSS bitcell_6t
XC25_110 BL110 BLB110 WL25 VDD VSS bitcell_6t
XC25_111 BL111 BLB111 WL25 VDD VSS bitcell_6t
XC25_112 BL112 BLB112 WL25 VDD VSS bitcell_6t
XC25_113 BL113 BLB113 WL25 VDD VSS bitcell_6t
XC25_114 BL114 BLB114 WL25 VDD VSS bitcell_6t
XC25_115 BL115 BLB115 WL25 VDD VSS bitcell_6t
XC25_116 BL116 BLB116 WL25 VDD VSS bitcell_6t
XC25_117 BL117 BLB117 WL25 VDD VSS bitcell_6t
XC25_118 BL118 BLB118 WL25 VDD VSS bitcell_6t
XC25_119 BL119 BLB119 WL25 VDD VSS bitcell_6t
XC25_120 BL120 BLB120 WL25 VDD VSS bitcell_6t
XC25_121 BL121 BLB121 WL25 VDD VSS bitcell_6t
XC25_122 BL122 BLB122 WL25 VDD VSS bitcell_6t
XC25_123 BL123 BLB123 WL25 VDD VSS bitcell_6t
XC25_124 BL124 BLB124 WL25 VDD VSS bitcell_6t
XC25_125 BL125 BLB125 WL25 VDD VSS bitcell_6t
XC25_126 BL126 BLB126 WL25 VDD VSS bitcell_6t
XC25_127 BL127 BLB127 WL25 VDD VSS bitcell_6t
XC26_0 BL0 BLB0 WL26 VDD VSS bitcell_6t
XC26_1 BL1 BLB1 WL26 VDD VSS bitcell_6t
XC26_2 BL2 BLB2 WL26 VDD VSS bitcell_6t
XC26_3 BL3 BLB3 WL26 VDD VSS bitcell_6t
XC26_4 BL4 BLB4 WL26 VDD VSS bitcell_6t
XC26_5 BL5 BLB5 WL26 VDD VSS bitcell_6t
XC26_6 BL6 BLB6 WL26 VDD VSS bitcell_6t
XC26_7 BL7 BLB7 WL26 VDD VSS bitcell_6t
XC26_8 BL8 BLB8 WL26 VDD VSS bitcell_6t
XC26_9 BL9 BLB9 WL26 VDD VSS bitcell_6t
XC26_10 BL10 BLB10 WL26 VDD VSS bitcell_6t
XC26_11 BL11 BLB11 WL26 VDD VSS bitcell_6t
XC26_12 BL12 BLB12 WL26 VDD VSS bitcell_6t
XC26_13 BL13 BLB13 WL26 VDD VSS bitcell_6t
XC26_14 BL14 BLB14 WL26 VDD VSS bitcell_6t
XC26_15 BL15 BLB15 WL26 VDD VSS bitcell_6t
XC26_16 BL16 BLB16 WL26 VDD VSS bitcell_6t
XC26_17 BL17 BLB17 WL26 VDD VSS bitcell_6t
XC26_18 BL18 BLB18 WL26 VDD VSS bitcell_6t
XC26_19 BL19 BLB19 WL26 VDD VSS bitcell_6t
XC26_20 BL20 BLB20 WL26 VDD VSS bitcell_6t
XC26_21 BL21 BLB21 WL26 VDD VSS bitcell_6t
XC26_22 BL22 BLB22 WL26 VDD VSS bitcell_6t
XC26_23 BL23 BLB23 WL26 VDD VSS bitcell_6t
XC26_24 BL24 BLB24 WL26 VDD VSS bitcell_6t
XC26_25 BL25 BLB25 WL26 VDD VSS bitcell_6t
XC26_26 BL26 BLB26 WL26 VDD VSS bitcell_6t
XC26_27 BL27 BLB27 WL26 VDD VSS bitcell_6t
XC26_28 BL28 BLB28 WL26 VDD VSS bitcell_6t
XC26_29 BL29 BLB29 WL26 VDD VSS bitcell_6t
XC26_30 BL30 BLB30 WL26 VDD VSS bitcell_6t
XC26_31 BL31 BLB31 WL26 VDD VSS bitcell_6t
XC26_32 BL32 BLB32 WL26 VDD VSS bitcell_6t
XC26_33 BL33 BLB33 WL26 VDD VSS bitcell_6t
XC26_34 BL34 BLB34 WL26 VDD VSS bitcell_6t
XC26_35 BL35 BLB35 WL26 VDD VSS bitcell_6t
XC26_36 BL36 BLB36 WL26 VDD VSS bitcell_6t
XC26_37 BL37 BLB37 WL26 VDD VSS bitcell_6t
XC26_38 BL38 BLB38 WL26 VDD VSS bitcell_6t
XC26_39 BL39 BLB39 WL26 VDD VSS bitcell_6t
XC26_40 BL40 BLB40 WL26 VDD VSS bitcell_6t
XC26_41 BL41 BLB41 WL26 VDD VSS bitcell_6t
XC26_42 BL42 BLB42 WL26 VDD VSS bitcell_6t
XC26_43 BL43 BLB43 WL26 VDD VSS bitcell_6t
XC26_44 BL44 BLB44 WL26 VDD VSS bitcell_6t
XC26_45 BL45 BLB45 WL26 VDD VSS bitcell_6t
XC26_46 BL46 BLB46 WL26 VDD VSS bitcell_6t
XC26_47 BL47 BLB47 WL26 VDD VSS bitcell_6t
XC26_48 BL48 BLB48 WL26 VDD VSS bitcell_6t
XC26_49 BL49 BLB49 WL26 VDD VSS bitcell_6t
XC26_50 BL50 BLB50 WL26 VDD VSS bitcell_6t
XC26_51 BL51 BLB51 WL26 VDD VSS bitcell_6t
XC26_52 BL52 BLB52 WL26 VDD VSS bitcell_6t
XC26_53 BL53 BLB53 WL26 VDD VSS bitcell_6t
XC26_54 BL54 BLB54 WL26 VDD VSS bitcell_6t
XC26_55 BL55 BLB55 WL26 VDD VSS bitcell_6t
XC26_56 BL56 BLB56 WL26 VDD VSS bitcell_6t
XC26_57 BL57 BLB57 WL26 VDD VSS bitcell_6t
XC26_58 BL58 BLB58 WL26 VDD VSS bitcell_6t
XC26_59 BL59 BLB59 WL26 VDD VSS bitcell_6t
XC26_60 BL60 BLB60 WL26 VDD VSS bitcell_6t
XC26_61 BL61 BLB61 WL26 VDD VSS bitcell_6t
XC26_62 BL62 BLB62 WL26 VDD VSS bitcell_6t
XC26_63 BL63 BLB63 WL26 VDD VSS bitcell_6t
XC26_64 BL64 BLB64 WL26 VDD VSS bitcell_6t
XC26_65 BL65 BLB65 WL26 VDD VSS bitcell_6t
XC26_66 BL66 BLB66 WL26 VDD VSS bitcell_6t
XC26_67 BL67 BLB67 WL26 VDD VSS bitcell_6t
XC26_68 BL68 BLB68 WL26 VDD VSS bitcell_6t
XC26_69 BL69 BLB69 WL26 VDD VSS bitcell_6t
XC26_70 BL70 BLB70 WL26 VDD VSS bitcell_6t
XC26_71 BL71 BLB71 WL26 VDD VSS bitcell_6t
XC26_72 BL72 BLB72 WL26 VDD VSS bitcell_6t
XC26_73 BL73 BLB73 WL26 VDD VSS bitcell_6t
XC26_74 BL74 BLB74 WL26 VDD VSS bitcell_6t
XC26_75 BL75 BLB75 WL26 VDD VSS bitcell_6t
XC26_76 BL76 BLB76 WL26 VDD VSS bitcell_6t
XC26_77 BL77 BLB77 WL26 VDD VSS bitcell_6t
XC26_78 BL78 BLB78 WL26 VDD VSS bitcell_6t
XC26_79 BL79 BLB79 WL26 VDD VSS bitcell_6t
XC26_80 BL80 BLB80 WL26 VDD VSS bitcell_6t
XC26_81 BL81 BLB81 WL26 VDD VSS bitcell_6t
XC26_82 BL82 BLB82 WL26 VDD VSS bitcell_6t
XC26_83 BL83 BLB83 WL26 VDD VSS bitcell_6t
XC26_84 BL84 BLB84 WL26 VDD VSS bitcell_6t
XC26_85 BL85 BLB85 WL26 VDD VSS bitcell_6t
XC26_86 BL86 BLB86 WL26 VDD VSS bitcell_6t
XC26_87 BL87 BLB87 WL26 VDD VSS bitcell_6t
XC26_88 BL88 BLB88 WL26 VDD VSS bitcell_6t
XC26_89 BL89 BLB89 WL26 VDD VSS bitcell_6t
XC26_90 BL90 BLB90 WL26 VDD VSS bitcell_6t
XC26_91 BL91 BLB91 WL26 VDD VSS bitcell_6t
XC26_92 BL92 BLB92 WL26 VDD VSS bitcell_6t
XC26_93 BL93 BLB93 WL26 VDD VSS bitcell_6t
XC26_94 BL94 BLB94 WL26 VDD VSS bitcell_6t
XC26_95 BL95 BLB95 WL26 VDD VSS bitcell_6t
XC26_96 BL96 BLB96 WL26 VDD VSS bitcell_6t
XC26_97 BL97 BLB97 WL26 VDD VSS bitcell_6t
XC26_98 BL98 BLB98 WL26 VDD VSS bitcell_6t
XC26_99 BL99 BLB99 WL26 VDD VSS bitcell_6t
XC26_100 BL100 BLB100 WL26 VDD VSS bitcell_6t
XC26_101 BL101 BLB101 WL26 VDD VSS bitcell_6t
XC26_102 BL102 BLB102 WL26 VDD VSS bitcell_6t
XC26_103 BL103 BLB103 WL26 VDD VSS bitcell_6t
XC26_104 BL104 BLB104 WL26 VDD VSS bitcell_6t
XC26_105 BL105 BLB105 WL26 VDD VSS bitcell_6t
XC26_106 BL106 BLB106 WL26 VDD VSS bitcell_6t
XC26_107 BL107 BLB107 WL26 VDD VSS bitcell_6t
XC26_108 BL108 BLB108 WL26 VDD VSS bitcell_6t
XC26_109 BL109 BLB109 WL26 VDD VSS bitcell_6t
XC26_110 BL110 BLB110 WL26 VDD VSS bitcell_6t
XC26_111 BL111 BLB111 WL26 VDD VSS bitcell_6t
XC26_112 BL112 BLB112 WL26 VDD VSS bitcell_6t
XC26_113 BL113 BLB113 WL26 VDD VSS bitcell_6t
XC26_114 BL114 BLB114 WL26 VDD VSS bitcell_6t
XC26_115 BL115 BLB115 WL26 VDD VSS bitcell_6t
XC26_116 BL116 BLB116 WL26 VDD VSS bitcell_6t
XC26_117 BL117 BLB117 WL26 VDD VSS bitcell_6t
XC26_118 BL118 BLB118 WL26 VDD VSS bitcell_6t
XC26_119 BL119 BLB119 WL26 VDD VSS bitcell_6t
XC26_120 BL120 BLB120 WL26 VDD VSS bitcell_6t
XC26_121 BL121 BLB121 WL26 VDD VSS bitcell_6t
XC26_122 BL122 BLB122 WL26 VDD VSS bitcell_6t
XC26_123 BL123 BLB123 WL26 VDD VSS bitcell_6t
XC26_124 BL124 BLB124 WL26 VDD VSS bitcell_6t
XC26_125 BL125 BLB125 WL26 VDD VSS bitcell_6t
XC26_126 BL126 BLB126 WL26 VDD VSS bitcell_6t
XC26_127 BL127 BLB127 WL26 VDD VSS bitcell_6t
XC27_0 BL0 BLB0 WL27 VDD VSS bitcell_6t
XC27_1 BL1 BLB1 WL27 VDD VSS bitcell_6t
XC27_2 BL2 BLB2 WL27 VDD VSS bitcell_6t
XC27_3 BL3 BLB3 WL27 VDD VSS bitcell_6t
XC27_4 BL4 BLB4 WL27 VDD VSS bitcell_6t
XC27_5 BL5 BLB5 WL27 VDD VSS bitcell_6t
XC27_6 BL6 BLB6 WL27 VDD VSS bitcell_6t
XC27_7 BL7 BLB7 WL27 VDD VSS bitcell_6t
XC27_8 BL8 BLB8 WL27 VDD VSS bitcell_6t
XC27_9 BL9 BLB9 WL27 VDD VSS bitcell_6t
XC27_10 BL10 BLB10 WL27 VDD VSS bitcell_6t
XC27_11 BL11 BLB11 WL27 VDD VSS bitcell_6t
XC27_12 BL12 BLB12 WL27 VDD VSS bitcell_6t
XC27_13 BL13 BLB13 WL27 VDD VSS bitcell_6t
XC27_14 BL14 BLB14 WL27 VDD VSS bitcell_6t
XC27_15 BL15 BLB15 WL27 VDD VSS bitcell_6t
XC27_16 BL16 BLB16 WL27 VDD VSS bitcell_6t
XC27_17 BL17 BLB17 WL27 VDD VSS bitcell_6t
XC27_18 BL18 BLB18 WL27 VDD VSS bitcell_6t
XC27_19 BL19 BLB19 WL27 VDD VSS bitcell_6t
XC27_20 BL20 BLB20 WL27 VDD VSS bitcell_6t
XC27_21 BL21 BLB21 WL27 VDD VSS bitcell_6t
XC27_22 BL22 BLB22 WL27 VDD VSS bitcell_6t
XC27_23 BL23 BLB23 WL27 VDD VSS bitcell_6t
XC27_24 BL24 BLB24 WL27 VDD VSS bitcell_6t
XC27_25 BL25 BLB25 WL27 VDD VSS bitcell_6t
XC27_26 BL26 BLB26 WL27 VDD VSS bitcell_6t
XC27_27 BL27 BLB27 WL27 VDD VSS bitcell_6t
XC27_28 BL28 BLB28 WL27 VDD VSS bitcell_6t
XC27_29 BL29 BLB29 WL27 VDD VSS bitcell_6t
XC27_30 BL30 BLB30 WL27 VDD VSS bitcell_6t
XC27_31 BL31 BLB31 WL27 VDD VSS bitcell_6t
XC27_32 BL32 BLB32 WL27 VDD VSS bitcell_6t
XC27_33 BL33 BLB33 WL27 VDD VSS bitcell_6t
XC27_34 BL34 BLB34 WL27 VDD VSS bitcell_6t
XC27_35 BL35 BLB35 WL27 VDD VSS bitcell_6t
XC27_36 BL36 BLB36 WL27 VDD VSS bitcell_6t
XC27_37 BL37 BLB37 WL27 VDD VSS bitcell_6t
XC27_38 BL38 BLB38 WL27 VDD VSS bitcell_6t
XC27_39 BL39 BLB39 WL27 VDD VSS bitcell_6t
XC27_40 BL40 BLB40 WL27 VDD VSS bitcell_6t
XC27_41 BL41 BLB41 WL27 VDD VSS bitcell_6t
XC27_42 BL42 BLB42 WL27 VDD VSS bitcell_6t
XC27_43 BL43 BLB43 WL27 VDD VSS bitcell_6t
XC27_44 BL44 BLB44 WL27 VDD VSS bitcell_6t
XC27_45 BL45 BLB45 WL27 VDD VSS bitcell_6t
XC27_46 BL46 BLB46 WL27 VDD VSS bitcell_6t
XC27_47 BL47 BLB47 WL27 VDD VSS bitcell_6t
XC27_48 BL48 BLB48 WL27 VDD VSS bitcell_6t
XC27_49 BL49 BLB49 WL27 VDD VSS bitcell_6t
XC27_50 BL50 BLB50 WL27 VDD VSS bitcell_6t
XC27_51 BL51 BLB51 WL27 VDD VSS bitcell_6t
XC27_52 BL52 BLB52 WL27 VDD VSS bitcell_6t
XC27_53 BL53 BLB53 WL27 VDD VSS bitcell_6t
XC27_54 BL54 BLB54 WL27 VDD VSS bitcell_6t
XC27_55 BL55 BLB55 WL27 VDD VSS bitcell_6t
XC27_56 BL56 BLB56 WL27 VDD VSS bitcell_6t
XC27_57 BL57 BLB57 WL27 VDD VSS bitcell_6t
XC27_58 BL58 BLB58 WL27 VDD VSS bitcell_6t
XC27_59 BL59 BLB59 WL27 VDD VSS bitcell_6t
XC27_60 BL60 BLB60 WL27 VDD VSS bitcell_6t
XC27_61 BL61 BLB61 WL27 VDD VSS bitcell_6t
XC27_62 BL62 BLB62 WL27 VDD VSS bitcell_6t
XC27_63 BL63 BLB63 WL27 VDD VSS bitcell_6t
XC27_64 BL64 BLB64 WL27 VDD VSS bitcell_6t
XC27_65 BL65 BLB65 WL27 VDD VSS bitcell_6t
XC27_66 BL66 BLB66 WL27 VDD VSS bitcell_6t
XC27_67 BL67 BLB67 WL27 VDD VSS bitcell_6t
XC27_68 BL68 BLB68 WL27 VDD VSS bitcell_6t
XC27_69 BL69 BLB69 WL27 VDD VSS bitcell_6t
XC27_70 BL70 BLB70 WL27 VDD VSS bitcell_6t
XC27_71 BL71 BLB71 WL27 VDD VSS bitcell_6t
XC27_72 BL72 BLB72 WL27 VDD VSS bitcell_6t
XC27_73 BL73 BLB73 WL27 VDD VSS bitcell_6t
XC27_74 BL74 BLB74 WL27 VDD VSS bitcell_6t
XC27_75 BL75 BLB75 WL27 VDD VSS bitcell_6t
XC27_76 BL76 BLB76 WL27 VDD VSS bitcell_6t
XC27_77 BL77 BLB77 WL27 VDD VSS bitcell_6t
XC27_78 BL78 BLB78 WL27 VDD VSS bitcell_6t
XC27_79 BL79 BLB79 WL27 VDD VSS bitcell_6t
XC27_80 BL80 BLB80 WL27 VDD VSS bitcell_6t
XC27_81 BL81 BLB81 WL27 VDD VSS bitcell_6t
XC27_82 BL82 BLB82 WL27 VDD VSS bitcell_6t
XC27_83 BL83 BLB83 WL27 VDD VSS bitcell_6t
XC27_84 BL84 BLB84 WL27 VDD VSS bitcell_6t
XC27_85 BL85 BLB85 WL27 VDD VSS bitcell_6t
XC27_86 BL86 BLB86 WL27 VDD VSS bitcell_6t
XC27_87 BL87 BLB87 WL27 VDD VSS bitcell_6t
XC27_88 BL88 BLB88 WL27 VDD VSS bitcell_6t
XC27_89 BL89 BLB89 WL27 VDD VSS bitcell_6t
XC27_90 BL90 BLB90 WL27 VDD VSS bitcell_6t
XC27_91 BL91 BLB91 WL27 VDD VSS bitcell_6t
XC27_92 BL92 BLB92 WL27 VDD VSS bitcell_6t
XC27_93 BL93 BLB93 WL27 VDD VSS bitcell_6t
XC27_94 BL94 BLB94 WL27 VDD VSS bitcell_6t
XC27_95 BL95 BLB95 WL27 VDD VSS bitcell_6t
XC27_96 BL96 BLB96 WL27 VDD VSS bitcell_6t
XC27_97 BL97 BLB97 WL27 VDD VSS bitcell_6t
XC27_98 BL98 BLB98 WL27 VDD VSS bitcell_6t
XC27_99 BL99 BLB99 WL27 VDD VSS bitcell_6t
XC27_100 BL100 BLB100 WL27 VDD VSS bitcell_6t
XC27_101 BL101 BLB101 WL27 VDD VSS bitcell_6t
XC27_102 BL102 BLB102 WL27 VDD VSS bitcell_6t
XC27_103 BL103 BLB103 WL27 VDD VSS bitcell_6t
XC27_104 BL104 BLB104 WL27 VDD VSS bitcell_6t
XC27_105 BL105 BLB105 WL27 VDD VSS bitcell_6t
XC27_106 BL106 BLB106 WL27 VDD VSS bitcell_6t
XC27_107 BL107 BLB107 WL27 VDD VSS bitcell_6t
XC27_108 BL108 BLB108 WL27 VDD VSS bitcell_6t
XC27_109 BL109 BLB109 WL27 VDD VSS bitcell_6t
XC27_110 BL110 BLB110 WL27 VDD VSS bitcell_6t
XC27_111 BL111 BLB111 WL27 VDD VSS bitcell_6t
XC27_112 BL112 BLB112 WL27 VDD VSS bitcell_6t
XC27_113 BL113 BLB113 WL27 VDD VSS bitcell_6t
XC27_114 BL114 BLB114 WL27 VDD VSS bitcell_6t
XC27_115 BL115 BLB115 WL27 VDD VSS bitcell_6t
XC27_116 BL116 BLB116 WL27 VDD VSS bitcell_6t
XC27_117 BL117 BLB117 WL27 VDD VSS bitcell_6t
XC27_118 BL118 BLB118 WL27 VDD VSS bitcell_6t
XC27_119 BL119 BLB119 WL27 VDD VSS bitcell_6t
XC27_120 BL120 BLB120 WL27 VDD VSS bitcell_6t
XC27_121 BL121 BLB121 WL27 VDD VSS bitcell_6t
XC27_122 BL122 BLB122 WL27 VDD VSS bitcell_6t
XC27_123 BL123 BLB123 WL27 VDD VSS bitcell_6t
XC27_124 BL124 BLB124 WL27 VDD VSS bitcell_6t
XC27_125 BL125 BLB125 WL27 VDD VSS bitcell_6t
XC27_126 BL126 BLB126 WL27 VDD VSS bitcell_6t
XC27_127 BL127 BLB127 WL27 VDD VSS bitcell_6t
XC28_0 BL0 BLB0 WL28 VDD VSS bitcell_6t
XC28_1 BL1 BLB1 WL28 VDD VSS bitcell_6t
XC28_2 BL2 BLB2 WL28 VDD VSS bitcell_6t
XC28_3 BL3 BLB3 WL28 VDD VSS bitcell_6t
XC28_4 BL4 BLB4 WL28 VDD VSS bitcell_6t
XC28_5 BL5 BLB5 WL28 VDD VSS bitcell_6t
XC28_6 BL6 BLB6 WL28 VDD VSS bitcell_6t
XC28_7 BL7 BLB7 WL28 VDD VSS bitcell_6t
XC28_8 BL8 BLB8 WL28 VDD VSS bitcell_6t
XC28_9 BL9 BLB9 WL28 VDD VSS bitcell_6t
XC28_10 BL10 BLB10 WL28 VDD VSS bitcell_6t
XC28_11 BL11 BLB11 WL28 VDD VSS bitcell_6t
XC28_12 BL12 BLB12 WL28 VDD VSS bitcell_6t
XC28_13 BL13 BLB13 WL28 VDD VSS bitcell_6t
XC28_14 BL14 BLB14 WL28 VDD VSS bitcell_6t
XC28_15 BL15 BLB15 WL28 VDD VSS bitcell_6t
XC28_16 BL16 BLB16 WL28 VDD VSS bitcell_6t
XC28_17 BL17 BLB17 WL28 VDD VSS bitcell_6t
XC28_18 BL18 BLB18 WL28 VDD VSS bitcell_6t
XC28_19 BL19 BLB19 WL28 VDD VSS bitcell_6t
XC28_20 BL20 BLB20 WL28 VDD VSS bitcell_6t
XC28_21 BL21 BLB21 WL28 VDD VSS bitcell_6t
XC28_22 BL22 BLB22 WL28 VDD VSS bitcell_6t
XC28_23 BL23 BLB23 WL28 VDD VSS bitcell_6t
XC28_24 BL24 BLB24 WL28 VDD VSS bitcell_6t
XC28_25 BL25 BLB25 WL28 VDD VSS bitcell_6t
XC28_26 BL26 BLB26 WL28 VDD VSS bitcell_6t
XC28_27 BL27 BLB27 WL28 VDD VSS bitcell_6t
XC28_28 BL28 BLB28 WL28 VDD VSS bitcell_6t
XC28_29 BL29 BLB29 WL28 VDD VSS bitcell_6t
XC28_30 BL30 BLB30 WL28 VDD VSS bitcell_6t
XC28_31 BL31 BLB31 WL28 VDD VSS bitcell_6t
XC28_32 BL32 BLB32 WL28 VDD VSS bitcell_6t
XC28_33 BL33 BLB33 WL28 VDD VSS bitcell_6t
XC28_34 BL34 BLB34 WL28 VDD VSS bitcell_6t
XC28_35 BL35 BLB35 WL28 VDD VSS bitcell_6t
XC28_36 BL36 BLB36 WL28 VDD VSS bitcell_6t
XC28_37 BL37 BLB37 WL28 VDD VSS bitcell_6t
XC28_38 BL38 BLB38 WL28 VDD VSS bitcell_6t
XC28_39 BL39 BLB39 WL28 VDD VSS bitcell_6t
XC28_40 BL40 BLB40 WL28 VDD VSS bitcell_6t
XC28_41 BL41 BLB41 WL28 VDD VSS bitcell_6t
XC28_42 BL42 BLB42 WL28 VDD VSS bitcell_6t
XC28_43 BL43 BLB43 WL28 VDD VSS bitcell_6t
XC28_44 BL44 BLB44 WL28 VDD VSS bitcell_6t
XC28_45 BL45 BLB45 WL28 VDD VSS bitcell_6t
XC28_46 BL46 BLB46 WL28 VDD VSS bitcell_6t
XC28_47 BL47 BLB47 WL28 VDD VSS bitcell_6t
XC28_48 BL48 BLB48 WL28 VDD VSS bitcell_6t
XC28_49 BL49 BLB49 WL28 VDD VSS bitcell_6t
XC28_50 BL50 BLB50 WL28 VDD VSS bitcell_6t
XC28_51 BL51 BLB51 WL28 VDD VSS bitcell_6t
XC28_52 BL52 BLB52 WL28 VDD VSS bitcell_6t
XC28_53 BL53 BLB53 WL28 VDD VSS bitcell_6t
XC28_54 BL54 BLB54 WL28 VDD VSS bitcell_6t
XC28_55 BL55 BLB55 WL28 VDD VSS bitcell_6t
XC28_56 BL56 BLB56 WL28 VDD VSS bitcell_6t
XC28_57 BL57 BLB57 WL28 VDD VSS bitcell_6t
XC28_58 BL58 BLB58 WL28 VDD VSS bitcell_6t
XC28_59 BL59 BLB59 WL28 VDD VSS bitcell_6t
XC28_60 BL60 BLB60 WL28 VDD VSS bitcell_6t
XC28_61 BL61 BLB61 WL28 VDD VSS bitcell_6t
XC28_62 BL62 BLB62 WL28 VDD VSS bitcell_6t
XC28_63 BL63 BLB63 WL28 VDD VSS bitcell_6t
XC28_64 BL64 BLB64 WL28 VDD VSS bitcell_6t
XC28_65 BL65 BLB65 WL28 VDD VSS bitcell_6t
XC28_66 BL66 BLB66 WL28 VDD VSS bitcell_6t
XC28_67 BL67 BLB67 WL28 VDD VSS bitcell_6t
XC28_68 BL68 BLB68 WL28 VDD VSS bitcell_6t
XC28_69 BL69 BLB69 WL28 VDD VSS bitcell_6t
XC28_70 BL70 BLB70 WL28 VDD VSS bitcell_6t
XC28_71 BL71 BLB71 WL28 VDD VSS bitcell_6t
XC28_72 BL72 BLB72 WL28 VDD VSS bitcell_6t
XC28_73 BL73 BLB73 WL28 VDD VSS bitcell_6t
XC28_74 BL74 BLB74 WL28 VDD VSS bitcell_6t
XC28_75 BL75 BLB75 WL28 VDD VSS bitcell_6t
XC28_76 BL76 BLB76 WL28 VDD VSS bitcell_6t
XC28_77 BL77 BLB77 WL28 VDD VSS bitcell_6t
XC28_78 BL78 BLB78 WL28 VDD VSS bitcell_6t
XC28_79 BL79 BLB79 WL28 VDD VSS bitcell_6t
XC28_80 BL80 BLB80 WL28 VDD VSS bitcell_6t
XC28_81 BL81 BLB81 WL28 VDD VSS bitcell_6t
XC28_82 BL82 BLB82 WL28 VDD VSS bitcell_6t
XC28_83 BL83 BLB83 WL28 VDD VSS bitcell_6t
XC28_84 BL84 BLB84 WL28 VDD VSS bitcell_6t
XC28_85 BL85 BLB85 WL28 VDD VSS bitcell_6t
XC28_86 BL86 BLB86 WL28 VDD VSS bitcell_6t
XC28_87 BL87 BLB87 WL28 VDD VSS bitcell_6t
XC28_88 BL88 BLB88 WL28 VDD VSS bitcell_6t
XC28_89 BL89 BLB89 WL28 VDD VSS bitcell_6t
XC28_90 BL90 BLB90 WL28 VDD VSS bitcell_6t
XC28_91 BL91 BLB91 WL28 VDD VSS bitcell_6t
XC28_92 BL92 BLB92 WL28 VDD VSS bitcell_6t
XC28_93 BL93 BLB93 WL28 VDD VSS bitcell_6t
XC28_94 BL94 BLB94 WL28 VDD VSS bitcell_6t
XC28_95 BL95 BLB95 WL28 VDD VSS bitcell_6t
XC28_96 BL96 BLB96 WL28 VDD VSS bitcell_6t
XC28_97 BL97 BLB97 WL28 VDD VSS bitcell_6t
XC28_98 BL98 BLB98 WL28 VDD VSS bitcell_6t
XC28_99 BL99 BLB99 WL28 VDD VSS bitcell_6t
XC28_100 BL100 BLB100 WL28 VDD VSS bitcell_6t
XC28_101 BL101 BLB101 WL28 VDD VSS bitcell_6t
XC28_102 BL102 BLB102 WL28 VDD VSS bitcell_6t
XC28_103 BL103 BLB103 WL28 VDD VSS bitcell_6t
XC28_104 BL104 BLB104 WL28 VDD VSS bitcell_6t
XC28_105 BL105 BLB105 WL28 VDD VSS bitcell_6t
XC28_106 BL106 BLB106 WL28 VDD VSS bitcell_6t
XC28_107 BL107 BLB107 WL28 VDD VSS bitcell_6t
XC28_108 BL108 BLB108 WL28 VDD VSS bitcell_6t
XC28_109 BL109 BLB109 WL28 VDD VSS bitcell_6t
XC28_110 BL110 BLB110 WL28 VDD VSS bitcell_6t
XC28_111 BL111 BLB111 WL28 VDD VSS bitcell_6t
XC28_112 BL112 BLB112 WL28 VDD VSS bitcell_6t
XC28_113 BL113 BLB113 WL28 VDD VSS bitcell_6t
XC28_114 BL114 BLB114 WL28 VDD VSS bitcell_6t
XC28_115 BL115 BLB115 WL28 VDD VSS bitcell_6t
XC28_116 BL116 BLB116 WL28 VDD VSS bitcell_6t
XC28_117 BL117 BLB117 WL28 VDD VSS bitcell_6t
XC28_118 BL118 BLB118 WL28 VDD VSS bitcell_6t
XC28_119 BL119 BLB119 WL28 VDD VSS bitcell_6t
XC28_120 BL120 BLB120 WL28 VDD VSS bitcell_6t
XC28_121 BL121 BLB121 WL28 VDD VSS bitcell_6t
XC28_122 BL122 BLB122 WL28 VDD VSS bitcell_6t
XC28_123 BL123 BLB123 WL28 VDD VSS bitcell_6t
XC28_124 BL124 BLB124 WL28 VDD VSS bitcell_6t
XC28_125 BL125 BLB125 WL28 VDD VSS bitcell_6t
XC28_126 BL126 BLB126 WL28 VDD VSS bitcell_6t
XC28_127 BL127 BLB127 WL28 VDD VSS bitcell_6t
XC29_0 BL0 BLB0 WL29 VDD VSS bitcell_6t
XC29_1 BL1 BLB1 WL29 VDD VSS bitcell_6t
XC29_2 BL2 BLB2 WL29 VDD VSS bitcell_6t
XC29_3 BL3 BLB3 WL29 VDD VSS bitcell_6t
XC29_4 BL4 BLB4 WL29 VDD VSS bitcell_6t
XC29_5 BL5 BLB5 WL29 VDD VSS bitcell_6t
XC29_6 BL6 BLB6 WL29 VDD VSS bitcell_6t
XC29_7 BL7 BLB7 WL29 VDD VSS bitcell_6t
XC29_8 BL8 BLB8 WL29 VDD VSS bitcell_6t
XC29_9 BL9 BLB9 WL29 VDD VSS bitcell_6t
XC29_10 BL10 BLB10 WL29 VDD VSS bitcell_6t
XC29_11 BL11 BLB11 WL29 VDD VSS bitcell_6t
XC29_12 BL12 BLB12 WL29 VDD VSS bitcell_6t
XC29_13 BL13 BLB13 WL29 VDD VSS bitcell_6t
XC29_14 BL14 BLB14 WL29 VDD VSS bitcell_6t
XC29_15 BL15 BLB15 WL29 VDD VSS bitcell_6t
XC29_16 BL16 BLB16 WL29 VDD VSS bitcell_6t
XC29_17 BL17 BLB17 WL29 VDD VSS bitcell_6t
XC29_18 BL18 BLB18 WL29 VDD VSS bitcell_6t
XC29_19 BL19 BLB19 WL29 VDD VSS bitcell_6t
XC29_20 BL20 BLB20 WL29 VDD VSS bitcell_6t
XC29_21 BL21 BLB21 WL29 VDD VSS bitcell_6t
XC29_22 BL22 BLB22 WL29 VDD VSS bitcell_6t
XC29_23 BL23 BLB23 WL29 VDD VSS bitcell_6t
XC29_24 BL24 BLB24 WL29 VDD VSS bitcell_6t
XC29_25 BL25 BLB25 WL29 VDD VSS bitcell_6t
XC29_26 BL26 BLB26 WL29 VDD VSS bitcell_6t
XC29_27 BL27 BLB27 WL29 VDD VSS bitcell_6t
XC29_28 BL28 BLB28 WL29 VDD VSS bitcell_6t
XC29_29 BL29 BLB29 WL29 VDD VSS bitcell_6t
XC29_30 BL30 BLB30 WL29 VDD VSS bitcell_6t
XC29_31 BL31 BLB31 WL29 VDD VSS bitcell_6t
XC29_32 BL32 BLB32 WL29 VDD VSS bitcell_6t
XC29_33 BL33 BLB33 WL29 VDD VSS bitcell_6t
XC29_34 BL34 BLB34 WL29 VDD VSS bitcell_6t
XC29_35 BL35 BLB35 WL29 VDD VSS bitcell_6t
XC29_36 BL36 BLB36 WL29 VDD VSS bitcell_6t
XC29_37 BL37 BLB37 WL29 VDD VSS bitcell_6t
XC29_38 BL38 BLB38 WL29 VDD VSS bitcell_6t
XC29_39 BL39 BLB39 WL29 VDD VSS bitcell_6t
XC29_40 BL40 BLB40 WL29 VDD VSS bitcell_6t
XC29_41 BL41 BLB41 WL29 VDD VSS bitcell_6t
XC29_42 BL42 BLB42 WL29 VDD VSS bitcell_6t
XC29_43 BL43 BLB43 WL29 VDD VSS bitcell_6t
XC29_44 BL44 BLB44 WL29 VDD VSS bitcell_6t
XC29_45 BL45 BLB45 WL29 VDD VSS bitcell_6t
XC29_46 BL46 BLB46 WL29 VDD VSS bitcell_6t
XC29_47 BL47 BLB47 WL29 VDD VSS bitcell_6t
XC29_48 BL48 BLB48 WL29 VDD VSS bitcell_6t
XC29_49 BL49 BLB49 WL29 VDD VSS bitcell_6t
XC29_50 BL50 BLB50 WL29 VDD VSS bitcell_6t
XC29_51 BL51 BLB51 WL29 VDD VSS bitcell_6t
XC29_52 BL52 BLB52 WL29 VDD VSS bitcell_6t
XC29_53 BL53 BLB53 WL29 VDD VSS bitcell_6t
XC29_54 BL54 BLB54 WL29 VDD VSS bitcell_6t
XC29_55 BL55 BLB55 WL29 VDD VSS bitcell_6t
XC29_56 BL56 BLB56 WL29 VDD VSS bitcell_6t
XC29_57 BL57 BLB57 WL29 VDD VSS bitcell_6t
XC29_58 BL58 BLB58 WL29 VDD VSS bitcell_6t
XC29_59 BL59 BLB59 WL29 VDD VSS bitcell_6t
XC29_60 BL60 BLB60 WL29 VDD VSS bitcell_6t
XC29_61 BL61 BLB61 WL29 VDD VSS bitcell_6t
XC29_62 BL62 BLB62 WL29 VDD VSS bitcell_6t
XC29_63 BL63 BLB63 WL29 VDD VSS bitcell_6t
XC29_64 BL64 BLB64 WL29 VDD VSS bitcell_6t
XC29_65 BL65 BLB65 WL29 VDD VSS bitcell_6t
XC29_66 BL66 BLB66 WL29 VDD VSS bitcell_6t
XC29_67 BL67 BLB67 WL29 VDD VSS bitcell_6t
XC29_68 BL68 BLB68 WL29 VDD VSS bitcell_6t
XC29_69 BL69 BLB69 WL29 VDD VSS bitcell_6t
XC29_70 BL70 BLB70 WL29 VDD VSS bitcell_6t
XC29_71 BL71 BLB71 WL29 VDD VSS bitcell_6t
XC29_72 BL72 BLB72 WL29 VDD VSS bitcell_6t
XC29_73 BL73 BLB73 WL29 VDD VSS bitcell_6t
XC29_74 BL74 BLB74 WL29 VDD VSS bitcell_6t
XC29_75 BL75 BLB75 WL29 VDD VSS bitcell_6t
XC29_76 BL76 BLB76 WL29 VDD VSS bitcell_6t
XC29_77 BL77 BLB77 WL29 VDD VSS bitcell_6t
XC29_78 BL78 BLB78 WL29 VDD VSS bitcell_6t
XC29_79 BL79 BLB79 WL29 VDD VSS bitcell_6t
XC29_80 BL80 BLB80 WL29 VDD VSS bitcell_6t
XC29_81 BL81 BLB81 WL29 VDD VSS bitcell_6t
XC29_82 BL82 BLB82 WL29 VDD VSS bitcell_6t
XC29_83 BL83 BLB83 WL29 VDD VSS bitcell_6t
XC29_84 BL84 BLB84 WL29 VDD VSS bitcell_6t
XC29_85 BL85 BLB85 WL29 VDD VSS bitcell_6t
XC29_86 BL86 BLB86 WL29 VDD VSS bitcell_6t
XC29_87 BL87 BLB87 WL29 VDD VSS bitcell_6t
XC29_88 BL88 BLB88 WL29 VDD VSS bitcell_6t
XC29_89 BL89 BLB89 WL29 VDD VSS bitcell_6t
XC29_90 BL90 BLB90 WL29 VDD VSS bitcell_6t
XC29_91 BL91 BLB91 WL29 VDD VSS bitcell_6t
XC29_92 BL92 BLB92 WL29 VDD VSS bitcell_6t
XC29_93 BL93 BLB93 WL29 VDD VSS bitcell_6t
XC29_94 BL94 BLB94 WL29 VDD VSS bitcell_6t
XC29_95 BL95 BLB95 WL29 VDD VSS bitcell_6t
XC29_96 BL96 BLB96 WL29 VDD VSS bitcell_6t
XC29_97 BL97 BLB97 WL29 VDD VSS bitcell_6t
XC29_98 BL98 BLB98 WL29 VDD VSS bitcell_6t
XC29_99 BL99 BLB99 WL29 VDD VSS bitcell_6t
XC29_100 BL100 BLB100 WL29 VDD VSS bitcell_6t
XC29_101 BL101 BLB101 WL29 VDD VSS bitcell_6t
XC29_102 BL102 BLB102 WL29 VDD VSS bitcell_6t
XC29_103 BL103 BLB103 WL29 VDD VSS bitcell_6t
XC29_104 BL104 BLB104 WL29 VDD VSS bitcell_6t
XC29_105 BL105 BLB105 WL29 VDD VSS bitcell_6t
XC29_106 BL106 BLB106 WL29 VDD VSS bitcell_6t
XC29_107 BL107 BLB107 WL29 VDD VSS bitcell_6t
XC29_108 BL108 BLB108 WL29 VDD VSS bitcell_6t
XC29_109 BL109 BLB109 WL29 VDD VSS bitcell_6t
XC29_110 BL110 BLB110 WL29 VDD VSS bitcell_6t
XC29_111 BL111 BLB111 WL29 VDD VSS bitcell_6t
XC29_112 BL112 BLB112 WL29 VDD VSS bitcell_6t
XC29_113 BL113 BLB113 WL29 VDD VSS bitcell_6t
XC29_114 BL114 BLB114 WL29 VDD VSS bitcell_6t
XC29_115 BL115 BLB115 WL29 VDD VSS bitcell_6t
XC29_116 BL116 BLB116 WL29 VDD VSS bitcell_6t
XC29_117 BL117 BLB117 WL29 VDD VSS bitcell_6t
XC29_118 BL118 BLB118 WL29 VDD VSS bitcell_6t
XC29_119 BL119 BLB119 WL29 VDD VSS bitcell_6t
XC29_120 BL120 BLB120 WL29 VDD VSS bitcell_6t
XC29_121 BL121 BLB121 WL29 VDD VSS bitcell_6t
XC29_122 BL122 BLB122 WL29 VDD VSS bitcell_6t
XC29_123 BL123 BLB123 WL29 VDD VSS bitcell_6t
XC29_124 BL124 BLB124 WL29 VDD VSS bitcell_6t
XC29_125 BL125 BLB125 WL29 VDD VSS bitcell_6t
XC29_126 BL126 BLB126 WL29 VDD VSS bitcell_6t
XC29_127 BL127 BLB127 WL29 VDD VSS bitcell_6t
XC30_0 BL0 BLB0 WL30 VDD VSS bitcell_6t
XC30_1 BL1 BLB1 WL30 VDD VSS bitcell_6t
XC30_2 BL2 BLB2 WL30 VDD VSS bitcell_6t
XC30_3 BL3 BLB3 WL30 VDD VSS bitcell_6t
XC30_4 BL4 BLB4 WL30 VDD VSS bitcell_6t
XC30_5 BL5 BLB5 WL30 VDD VSS bitcell_6t
XC30_6 BL6 BLB6 WL30 VDD VSS bitcell_6t
XC30_7 BL7 BLB7 WL30 VDD VSS bitcell_6t
XC30_8 BL8 BLB8 WL30 VDD VSS bitcell_6t
XC30_9 BL9 BLB9 WL30 VDD VSS bitcell_6t
XC30_10 BL10 BLB10 WL30 VDD VSS bitcell_6t
XC30_11 BL11 BLB11 WL30 VDD VSS bitcell_6t
XC30_12 BL12 BLB12 WL30 VDD VSS bitcell_6t
XC30_13 BL13 BLB13 WL30 VDD VSS bitcell_6t
XC30_14 BL14 BLB14 WL30 VDD VSS bitcell_6t
XC30_15 BL15 BLB15 WL30 VDD VSS bitcell_6t
XC30_16 BL16 BLB16 WL30 VDD VSS bitcell_6t
XC30_17 BL17 BLB17 WL30 VDD VSS bitcell_6t
XC30_18 BL18 BLB18 WL30 VDD VSS bitcell_6t
XC30_19 BL19 BLB19 WL30 VDD VSS bitcell_6t
XC30_20 BL20 BLB20 WL30 VDD VSS bitcell_6t
XC30_21 BL21 BLB21 WL30 VDD VSS bitcell_6t
XC30_22 BL22 BLB22 WL30 VDD VSS bitcell_6t
XC30_23 BL23 BLB23 WL30 VDD VSS bitcell_6t
XC30_24 BL24 BLB24 WL30 VDD VSS bitcell_6t
XC30_25 BL25 BLB25 WL30 VDD VSS bitcell_6t
XC30_26 BL26 BLB26 WL30 VDD VSS bitcell_6t
XC30_27 BL27 BLB27 WL30 VDD VSS bitcell_6t
XC30_28 BL28 BLB28 WL30 VDD VSS bitcell_6t
XC30_29 BL29 BLB29 WL30 VDD VSS bitcell_6t
XC30_30 BL30 BLB30 WL30 VDD VSS bitcell_6t
XC30_31 BL31 BLB31 WL30 VDD VSS bitcell_6t
XC30_32 BL32 BLB32 WL30 VDD VSS bitcell_6t
XC30_33 BL33 BLB33 WL30 VDD VSS bitcell_6t
XC30_34 BL34 BLB34 WL30 VDD VSS bitcell_6t
XC30_35 BL35 BLB35 WL30 VDD VSS bitcell_6t
XC30_36 BL36 BLB36 WL30 VDD VSS bitcell_6t
XC30_37 BL37 BLB37 WL30 VDD VSS bitcell_6t
XC30_38 BL38 BLB38 WL30 VDD VSS bitcell_6t
XC30_39 BL39 BLB39 WL30 VDD VSS bitcell_6t
XC30_40 BL40 BLB40 WL30 VDD VSS bitcell_6t
XC30_41 BL41 BLB41 WL30 VDD VSS bitcell_6t
XC30_42 BL42 BLB42 WL30 VDD VSS bitcell_6t
XC30_43 BL43 BLB43 WL30 VDD VSS bitcell_6t
XC30_44 BL44 BLB44 WL30 VDD VSS bitcell_6t
XC30_45 BL45 BLB45 WL30 VDD VSS bitcell_6t
XC30_46 BL46 BLB46 WL30 VDD VSS bitcell_6t
XC30_47 BL47 BLB47 WL30 VDD VSS bitcell_6t
XC30_48 BL48 BLB48 WL30 VDD VSS bitcell_6t
XC30_49 BL49 BLB49 WL30 VDD VSS bitcell_6t
XC30_50 BL50 BLB50 WL30 VDD VSS bitcell_6t
XC30_51 BL51 BLB51 WL30 VDD VSS bitcell_6t
XC30_52 BL52 BLB52 WL30 VDD VSS bitcell_6t
XC30_53 BL53 BLB53 WL30 VDD VSS bitcell_6t
XC30_54 BL54 BLB54 WL30 VDD VSS bitcell_6t
XC30_55 BL55 BLB55 WL30 VDD VSS bitcell_6t
XC30_56 BL56 BLB56 WL30 VDD VSS bitcell_6t
XC30_57 BL57 BLB57 WL30 VDD VSS bitcell_6t
XC30_58 BL58 BLB58 WL30 VDD VSS bitcell_6t
XC30_59 BL59 BLB59 WL30 VDD VSS bitcell_6t
XC30_60 BL60 BLB60 WL30 VDD VSS bitcell_6t
XC30_61 BL61 BLB61 WL30 VDD VSS bitcell_6t
XC30_62 BL62 BLB62 WL30 VDD VSS bitcell_6t
XC30_63 BL63 BLB63 WL30 VDD VSS bitcell_6t
XC30_64 BL64 BLB64 WL30 VDD VSS bitcell_6t
XC30_65 BL65 BLB65 WL30 VDD VSS bitcell_6t
XC30_66 BL66 BLB66 WL30 VDD VSS bitcell_6t
XC30_67 BL67 BLB67 WL30 VDD VSS bitcell_6t
XC30_68 BL68 BLB68 WL30 VDD VSS bitcell_6t
XC30_69 BL69 BLB69 WL30 VDD VSS bitcell_6t
XC30_70 BL70 BLB70 WL30 VDD VSS bitcell_6t
XC30_71 BL71 BLB71 WL30 VDD VSS bitcell_6t
XC30_72 BL72 BLB72 WL30 VDD VSS bitcell_6t
XC30_73 BL73 BLB73 WL30 VDD VSS bitcell_6t
XC30_74 BL74 BLB74 WL30 VDD VSS bitcell_6t
XC30_75 BL75 BLB75 WL30 VDD VSS bitcell_6t
XC30_76 BL76 BLB76 WL30 VDD VSS bitcell_6t
XC30_77 BL77 BLB77 WL30 VDD VSS bitcell_6t
XC30_78 BL78 BLB78 WL30 VDD VSS bitcell_6t
XC30_79 BL79 BLB79 WL30 VDD VSS bitcell_6t
XC30_80 BL80 BLB80 WL30 VDD VSS bitcell_6t
XC30_81 BL81 BLB81 WL30 VDD VSS bitcell_6t
XC30_82 BL82 BLB82 WL30 VDD VSS bitcell_6t
XC30_83 BL83 BLB83 WL30 VDD VSS bitcell_6t
XC30_84 BL84 BLB84 WL30 VDD VSS bitcell_6t
XC30_85 BL85 BLB85 WL30 VDD VSS bitcell_6t
XC30_86 BL86 BLB86 WL30 VDD VSS bitcell_6t
XC30_87 BL87 BLB87 WL30 VDD VSS bitcell_6t
XC30_88 BL88 BLB88 WL30 VDD VSS bitcell_6t
XC30_89 BL89 BLB89 WL30 VDD VSS bitcell_6t
XC30_90 BL90 BLB90 WL30 VDD VSS bitcell_6t
XC30_91 BL91 BLB91 WL30 VDD VSS bitcell_6t
XC30_92 BL92 BLB92 WL30 VDD VSS bitcell_6t
XC30_93 BL93 BLB93 WL30 VDD VSS bitcell_6t
XC30_94 BL94 BLB94 WL30 VDD VSS bitcell_6t
XC30_95 BL95 BLB95 WL30 VDD VSS bitcell_6t
XC30_96 BL96 BLB96 WL30 VDD VSS bitcell_6t
XC30_97 BL97 BLB97 WL30 VDD VSS bitcell_6t
XC30_98 BL98 BLB98 WL30 VDD VSS bitcell_6t
XC30_99 BL99 BLB99 WL30 VDD VSS bitcell_6t
XC30_100 BL100 BLB100 WL30 VDD VSS bitcell_6t
XC30_101 BL101 BLB101 WL30 VDD VSS bitcell_6t
XC30_102 BL102 BLB102 WL30 VDD VSS bitcell_6t
XC30_103 BL103 BLB103 WL30 VDD VSS bitcell_6t
XC30_104 BL104 BLB104 WL30 VDD VSS bitcell_6t
XC30_105 BL105 BLB105 WL30 VDD VSS bitcell_6t
XC30_106 BL106 BLB106 WL30 VDD VSS bitcell_6t
XC30_107 BL107 BLB107 WL30 VDD VSS bitcell_6t
XC30_108 BL108 BLB108 WL30 VDD VSS bitcell_6t
XC30_109 BL109 BLB109 WL30 VDD VSS bitcell_6t
XC30_110 BL110 BLB110 WL30 VDD VSS bitcell_6t
XC30_111 BL111 BLB111 WL30 VDD VSS bitcell_6t
XC30_112 BL112 BLB112 WL30 VDD VSS bitcell_6t
XC30_113 BL113 BLB113 WL30 VDD VSS bitcell_6t
XC30_114 BL114 BLB114 WL30 VDD VSS bitcell_6t
XC30_115 BL115 BLB115 WL30 VDD VSS bitcell_6t
XC30_116 BL116 BLB116 WL30 VDD VSS bitcell_6t
XC30_117 BL117 BLB117 WL30 VDD VSS bitcell_6t
XC30_118 BL118 BLB118 WL30 VDD VSS bitcell_6t
XC30_119 BL119 BLB119 WL30 VDD VSS bitcell_6t
XC30_120 BL120 BLB120 WL30 VDD VSS bitcell_6t
XC30_121 BL121 BLB121 WL30 VDD VSS bitcell_6t
XC30_122 BL122 BLB122 WL30 VDD VSS bitcell_6t
XC30_123 BL123 BLB123 WL30 VDD VSS bitcell_6t
XC30_124 BL124 BLB124 WL30 VDD VSS bitcell_6t
XC30_125 BL125 BLB125 WL30 VDD VSS bitcell_6t
XC30_126 BL126 BLB126 WL30 VDD VSS bitcell_6t
XC30_127 BL127 BLB127 WL30 VDD VSS bitcell_6t
XC31_0 BL0 BLB0 WL31 VDD VSS bitcell_6t
XC31_1 BL1 BLB1 WL31 VDD VSS bitcell_6t
XC31_2 BL2 BLB2 WL31 VDD VSS bitcell_6t
XC31_3 BL3 BLB3 WL31 VDD VSS bitcell_6t
XC31_4 BL4 BLB4 WL31 VDD VSS bitcell_6t
XC31_5 BL5 BLB5 WL31 VDD VSS bitcell_6t
XC31_6 BL6 BLB6 WL31 VDD VSS bitcell_6t
XC31_7 BL7 BLB7 WL31 VDD VSS bitcell_6t
XC31_8 BL8 BLB8 WL31 VDD VSS bitcell_6t
XC31_9 BL9 BLB9 WL31 VDD VSS bitcell_6t
XC31_10 BL10 BLB10 WL31 VDD VSS bitcell_6t
XC31_11 BL11 BLB11 WL31 VDD VSS bitcell_6t
XC31_12 BL12 BLB12 WL31 VDD VSS bitcell_6t
XC31_13 BL13 BLB13 WL31 VDD VSS bitcell_6t
XC31_14 BL14 BLB14 WL31 VDD VSS bitcell_6t
XC31_15 BL15 BLB15 WL31 VDD VSS bitcell_6t
XC31_16 BL16 BLB16 WL31 VDD VSS bitcell_6t
XC31_17 BL17 BLB17 WL31 VDD VSS bitcell_6t
XC31_18 BL18 BLB18 WL31 VDD VSS bitcell_6t
XC31_19 BL19 BLB19 WL31 VDD VSS bitcell_6t
XC31_20 BL20 BLB20 WL31 VDD VSS bitcell_6t
XC31_21 BL21 BLB21 WL31 VDD VSS bitcell_6t
XC31_22 BL22 BLB22 WL31 VDD VSS bitcell_6t
XC31_23 BL23 BLB23 WL31 VDD VSS bitcell_6t
XC31_24 BL24 BLB24 WL31 VDD VSS bitcell_6t
XC31_25 BL25 BLB25 WL31 VDD VSS bitcell_6t
XC31_26 BL26 BLB26 WL31 VDD VSS bitcell_6t
XC31_27 BL27 BLB27 WL31 VDD VSS bitcell_6t
XC31_28 BL28 BLB28 WL31 VDD VSS bitcell_6t
XC31_29 BL29 BLB29 WL31 VDD VSS bitcell_6t
XC31_30 BL30 BLB30 WL31 VDD VSS bitcell_6t
XC31_31 BL31 BLB31 WL31 VDD VSS bitcell_6t
XC31_32 BL32 BLB32 WL31 VDD VSS bitcell_6t
XC31_33 BL33 BLB33 WL31 VDD VSS bitcell_6t
XC31_34 BL34 BLB34 WL31 VDD VSS bitcell_6t
XC31_35 BL35 BLB35 WL31 VDD VSS bitcell_6t
XC31_36 BL36 BLB36 WL31 VDD VSS bitcell_6t
XC31_37 BL37 BLB37 WL31 VDD VSS bitcell_6t
XC31_38 BL38 BLB38 WL31 VDD VSS bitcell_6t
XC31_39 BL39 BLB39 WL31 VDD VSS bitcell_6t
XC31_40 BL40 BLB40 WL31 VDD VSS bitcell_6t
XC31_41 BL41 BLB41 WL31 VDD VSS bitcell_6t
XC31_42 BL42 BLB42 WL31 VDD VSS bitcell_6t
XC31_43 BL43 BLB43 WL31 VDD VSS bitcell_6t
XC31_44 BL44 BLB44 WL31 VDD VSS bitcell_6t
XC31_45 BL45 BLB45 WL31 VDD VSS bitcell_6t
XC31_46 BL46 BLB46 WL31 VDD VSS bitcell_6t
XC31_47 BL47 BLB47 WL31 VDD VSS bitcell_6t
XC31_48 BL48 BLB48 WL31 VDD VSS bitcell_6t
XC31_49 BL49 BLB49 WL31 VDD VSS bitcell_6t
XC31_50 BL50 BLB50 WL31 VDD VSS bitcell_6t
XC31_51 BL51 BLB51 WL31 VDD VSS bitcell_6t
XC31_52 BL52 BLB52 WL31 VDD VSS bitcell_6t
XC31_53 BL53 BLB53 WL31 VDD VSS bitcell_6t
XC31_54 BL54 BLB54 WL31 VDD VSS bitcell_6t
XC31_55 BL55 BLB55 WL31 VDD VSS bitcell_6t
XC31_56 BL56 BLB56 WL31 VDD VSS bitcell_6t
XC31_57 BL57 BLB57 WL31 VDD VSS bitcell_6t
XC31_58 BL58 BLB58 WL31 VDD VSS bitcell_6t
XC31_59 BL59 BLB59 WL31 VDD VSS bitcell_6t
XC31_60 BL60 BLB60 WL31 VDD VSS bitcell_6t
XC31_61 BL61 BLB61 WL31 VDD VSS bitcell_6t
XC31_62 BL62 BLB62 WL31 VDD VSS bitcell_6t
XC31_63 BL63 BLB63 WL31 VDD VSS bitcell_6t
XC31_64 BL64 BLB64 WL31 VDD VSS bitcell_6t
XC31_65 BL65 BLB65 WL31 VDD VSS bitcell_6t
XC31_66 BL66 BLB66 WL31 VDD VSS bitcell_6t
XC31_67 BL67 BLB67 WL31 VDD VSS bitcell_6t
XC31_68 BL68 BLB68 WL31 VDD VSS bitcell_6t
XC31_69 BL69 BLB69 WL31 VDD VSS bitcell_6t
XC31_70 BL70 BLB70 WL31 VDD VSS bitcell_6t
XC31_71 BL71 BLB71 WL31 VDD VSS bitcell_6t
XC31_72 BL72 BLB72 WL31 VDD VSS bitcell_6t
XC31_73 BL73 BLB73 WL31 VDD VSS bitcell_6t
XC31_74 BL74 BLB74 WL31 VDD VSS bitcell_6t
XC31_75 BL75 BLB75 WL31 VDD VSS bitcell_6t
XC31_76 BL76 BLB76 WL31 VDD VSS bitcell_6t
XC31_77 BL77 BLB77 WL31 VDD VSS bitcell_6t
XC31_78 BL78 BLB78 WL31 VDD VSS bitcell_6t
XC31_79 BL79 BLB79 WL31 VDD VSS bitcell_6t
XC31_80 BL80 BLB80 WL31 VDD VSS bitcell_6t
XC31_81 BL81 BLB81 WL31 VDD VSS bitcell_6t
XC31_82 BL82 BLB82 WL31 VDD VSS bitcell_6t
XC31_83 BL83 BLB83 WL31 VDD VSS bitcell_6t
XC31_84 BL84 BLB84 WL31 VDD VSS bitcell_6t
XC31_85 BL85 BLB85 WL31 VDD VSS bitcell_6t
XC31_86 BL86 BLB86 WL31 VDD VSS bitcell_6t
XC31_87 BL87 BLB87 WL31 VDD VSS bitcell_6t
XC31_88 BL88 BLB88 WL31 VDD VSS bitcell_6t
XC31_89 BL89 BLB89 WL31 VDD VSS bitcell_6t
XC31_90 BL90 BLB90 WL31 VDD VSS bitcell_6t
XC31_91 BL91 BLB91 WL31 VDD VSS bitcell_6t
XC31_92 BL92 BLB92 WL31 VDD VSS bitcell_6t
XC31_93 BL93 BLB93 WL31 VDD VSS bitcell_6t
XC31_94 BL94 BLB94 WL31 VDD VSS bitcell_6t
XC31_95 BL95 BLB95 WL31 VDD VSS bitcell_6t
XC31_96 BL96 BLB96 WL31 VDD VSS bitcell_6t
XC31_97 BL97 BLB97 WL31 VDD VSS bitcell_6t
XC31_98 BL98 BLB98 WL31 VDD VSS bitcell_6t
XC31_99 BL99 BLB99 WL31 VDD VSS bitcell_6t
XC31_100 BL100 BLB100 WL31 VDD VSS bitcell_6t
XC31_101 BL101 BLB101 WL31 VDD VSS bitcell_6t
XC31_102 BL102 BLB102 WL31 VDD VSS bitcell_6t
XC31_103 BL103 BLB103 WL31 VDD VSS bitcell_6t
XC31_104 BL104 BLB104 WL31 VDD VSS bitcell_6t
XC31_105 BL105 BLB105 WL31 VDD VSS bitcell_6t
XC31_106 BL106 BLB106 WL31 VDD VSS bitcell_6t
XC31_107 BL107 BLB107 WL31 VDD VSS bitcell_6t
XC31_108 BL108 BLB108 WL31 VDD VSS bitcell_6t
XC31_109 BL109 BLB109 WL31 VDD VSS bitcell_6t
XC31_110 BL110 BLB110 WL31 VDD VSS bitcell_6t
XC31_111 BL111 BLB111 WL31 VDD VSS bitcell_6t
XC31_112 BL112 BLB112 WL31 VDD VSS bitcell_6t
XC31_113 BL113 BLB113 WL31 VDD VSS bitcell_6t
XC31_114 BL114 BLB114 WL31 VDD VSS bitcell_6t
XC31_115 BL115 BLB115 WL31 VDD VSS bitcell_6t
XC31_116 BL116 BLB116 WL31 VDD VSS bitcell_6t
XC31_117 BL117 BLB117 WL31 VDD VSS bitcell_6t
XC31_118 BL118 BLB118 WL31 VDD VSS bitcell_6t
XC31_119 BL119 BLB119 WL31 VDD VSS bitcell_6t
XC31_120 BL120 BLB120 WL31 VDD VSS bitcell_6t
XC31_121 BL121 BLB121 WL31 VDD VSS bitcell_6t
XC31_122 BL122 BLB122 WL31 VDD VSS bitcell_6t
XC31_123 BL123 BLB123 WL31 VDD VSS bitcell_6t
XC31_124 BL124 BLB124 WL31 VDD VSS bitcell_6t
XC31_125 BL125 BLB125 WL31 VDD VSS bitcell_6t
XC31_126 BL126 BLB126 WL31 VDD VSS bitcell_6t
XC31_127 BL127 BLB127 WL31 VDD VSS bitcell_6t
XC32_0 BL0 BLB0 WL32 VDD VSS bitcell_6t
XC32_1 BL1 BLB1 WL32 VDD VSS bitcell_6t
XC32_2 BL2 BLB2 WL32 VDD VSS bitcell_6t
XC32_3 BL3 BLB3 WL32 VDD VSS bitcell_6t
XC32_4 BL4 BLB4 WL32 VDD VSS bitcell_6t
XC32_5 BL5 BLB5 WL32 VDD VSS bitcell_6t
XC32_6 BL6 BLB6 WL32 VDD VSS bitcell_6t
XC32_7 BL7 BLB7 WL32 VDD VSS bitcell_6t
XC32_8 BL8 BLB8 WL32 VDD VSS bitcell_6t
XC32_9 BL9 BLB9 WL32 VDD VSS bitcell_6t
XC32_10 BL10 BLB10 WL32 VDD VSS bitcell_6t
XC32_11 BL11 BLB11 WL32 VDD VSS bitcell_6t
XC32_12 BL12 BLB12 WL32 VDD VSS bitcell_6t
XC32_13 BL13 BLB13 WL32 VDD VSS bitcell_6t
XC32_14 BL14 BLB14 WL32 VDD VSS bitcell_6t
XC32_15 BL15 BLB15 WL32 VDD VSS bitcell_6t
XC32_16 BL16 BLB16 WL32 VDD VSS bitcell_6t
XC32_17 BL17 BLB17 WL32 VDD VSS bitcell_6t
XC32_18 BL18 BLB18 WL32 VDD VSS bitcell_6t
XC32_19 BL19 BLB19 WL32 VDD VSS bitcell_6t
XC32_20 BL20 BLB20 WL32 VDD VSS bitcell_6t
XC32_21 BL21 BLB21 WL32 VDD VSS bitcell_6t
XC32_22 BL22 BLB22 WL32 VDD VSS bitcell_6t
XC32_23 BL23 BLB23 WL32 VDD VSS bitcell_6t
XC32_24 BL24 BLB24 WL32 VDD VSS bitcell_6t
XC32_25 BL25 BLB25 WL32 VDD VSS bitcell_6t
XC32_26 BL26 BLB26 WL32 VDD VSS bitcell_6t
XC32_27 BL27 BLB27 WL32 VDD VSS bitcell_6t
XC32_28 BL28 BLB28 WL32 VDD VSS bitcell_6t
XC32_29 BL29 BLB29 WL32 VDD VSS bitcell_6t
XC32_30 BL30 BLB30 WL32 VDD VSS bitcell_6t
XC32_31 BL31 BLB31 WL32 VDD VSS bitcell_6t
XC32_32 BL32 BLB32 WL32 VDD VSS bitcell_6t
XC32_33 BL33 BLB33 WL32 VDD VSS bitcell_6t
XC32_34 BL34 BLB34 WL32 VDD VSS bitcell_6t
XC32_35 BL35 BLB35 WL32 VDD VSS bitcell_6t
XC32_36 BL36 BLB36 WL32 VDD VSS bitcell_6t
XC32_37 BL37 BLB37 WL32 VDD VSS bitcell_6t
XC32_38 BL38 BLB38 WL32 VDD VSS bitcell_6t
XC32_39 BL39 BLB39 WL32 VDD VSS bitcell_6t
XC32_40 BL40 BLB40 WL32 VDD VSS bitcell_6t
XC32_41 BL41 BLB41 WL32 VDD VSS bitcell_6t
XC32_42 BL42 BLB42 WL32 VDD VSS bitcell_6t
XC32_43 BL43 BLB43 WL32 VDD VSS bitcell_6t
XC32_44 BL44 BLB44 WL32 VDD VSS bitcell_6t
XC32_45 BL45 BLB45 WL32 VDD VSS bitcell_6t
XC32_46 BL46 BLB46 WL32 VDD VSS bitcell_6t
XC32_47 BL47 BLB47 WL32 VDD VSS bitcell_6t
XC32_48 BL48 BLB48 WL32 VDD VSS bitcell_6t
XC32_49 BL49 BLB49 WL32 VDD VSS bitcell_6t
XC32_50 BL50 BLB50 WL32 VDD VSS bitcell_6t
XC32_51 BL51 BLB51 WL32 VDD VSS bitcell_6t
XC32_52 BL52 BLB52 WL32 VDD VSS bitcell_6t
XC32_53 BL53 BLB53 WL32 VDD VSS bitcell_6t
XC32_54 BL54 BLB54 WL32 VDD VSS bitcell_6t
XC32_55 BL55 BLB55 WL32 VDD VSS bitcell_6t
XC32_56 BL56 BLB56 WL32 VDD VSS bitcell_6t
XC32_57 BL57 BLB57 WL32 VDD VSS bitcell_6t
XC32_58 BL58 BLB58 WL32 VDD VSS bitcell_6t
XC32_59 BL59 BLB59 WL32 VDD VSS bitcell_6t
XC32_60 BL60 BLB60 WL32 VDD VSS bitcell_6t
XC32_61 BL61 BLB61 WL32 VDD VSS bitcell_6t
XC32_62 BL62 BLB62 WL32 VDD VSS bitcell_6t
XC32_63 BL63 BLB63 WL32 VDD VSS bitcell_6t
XC32_64 BL64 BLB64 WL32 VDD VSS bitcell_6t
XC32_65 BL65 BLB65 WL32 VDD VSS bitcell_6t
XC32_66 BL66 BLB66 WL32 VDD VSS bitcell_6t
XC32_67 BL67 BLB67 WL32 VDD VSS bitcell_6t
XC32_68 BL68 BLB68 WL32 VDD VSS bitcell_6t
XC32_69 BL69 BLB69 WL32 VDD VSS bitcell_6t
XC32_70 BL70 BLB70 WL32 VDD VSS bitcell_6t
XC32_71 BL71 BLB71 WL32 VDD VSS bitcell_6t
XC32_72 BL72 BLB72 WL32 VDD VSS bitcell_6t
XC32_73 BL73 BLB73 WL32 VDD VSS bitcell_6t
XC32_74 BL74 BLB74 WL32 VDD VSS bitcell_6t
XC32_75 BL75 BLB75 WL32 VDD VSS bitcell_6t
XC32_76 BL76 BLB76 WL32 VDD VSS bitcell_6t
XC32_77 BL77 BLB77 WL32 VDD VSS bitcell_6t
XC32_78 BL78 BLB78 WL32 VDD VSS bitcell_6t
XC32_79 BL79 BLB79 WL32 VDD VSS bitcell_6t
XC32_80 BL80 BLB80 WL32 VDD VSS bitcell_6t
XC32_81 BL81 BLB81 WL32 VDD VSS bitcell_6t
XC32_82 BL82 BLB82 WL32 VDD VSS bitcell_6t
XC32_83 BL83 BLB83 WL32 VDD VSS bitcell_6t
XC32_84 BL84 BLB84 WL32 VDD VSS bitcell_6t
XC32_85 BL85 BLB85 WL32 VDD VSS bitcell_6t
XC32_86 BL86 BLB86 WL32 VDD VSS bitcell_6t
XC32_87 BL87 BLB87 WL32 VDD VSS bitcell_6t
XC32_88 BL88 BLB88 WL32 VDD VSS bitcell_6t
XC32_89 BL89 BLB89 WL32 VDD VSS bitcell_6t
XC32_90 BL90 BLB90 WL32 VDD VSS bitcell_6t
XC32_91 BL91 BLB91 WL32 VDD VSS bitcell_6t
XC32_92 BL92 BLB92 WL32 VDD VSS bitcell_6t
XC32_93 BL93 BLB93 WL32 VDD VSS bitcell_6t
XC32_94 BL94 BLB94 WL32 VDD VSS bitcell_6t
XC32_95 BL95 BLB95 WL32 VDD VSS bitcell_6t
XC32_96 BL96 BLB96 WL32 VDD VSS bitcell_6t
XC32_97 BL97 BLB97 WL32 VDD VSS bitcell_6t
XC32_98 BL98 BLB98 WL32 VDD VSS bitcell_6t
XC32_99 BL99 BLB99 WL32 VDD VSS bitcell_6t
XC32_100 BL100 BLB100 WL32 VDD VSS bitcell_6t
XC32_101 BL101 BLB101 WL32 VDD VSS bitcell_6t
XC32_102 BL102 BLB102 WL32 VDD VSS bitcell_6t
XC32_103 BL103 BLB103 WL32 VDD VSS bitcell_6t
XC32_104 BL104 BLB104 WL32 VDD VSS bitcell_6t
XC32_105 BL105 BLB105 WL32 VDD VSS bitcell_6t
XC32_106 BL106 BLB106 WL32 VDD VSS bitcell_6t
XC32_107 BL107 BLB107 WL32 VDD VSS bitcell_6t
XC32_108 BL108 BLB108 WL32 VDD VSS bitcell_6t
XC32_109 BL109 BLB109 WL32 VDD VSS bitcell_6t
XC32_110 BL110 BLB110 WL32 VDD VSS bitcell_6t
XC32_111 BL111 BLB111 WL32 VDD VSS bitcell_6t
XC32_112 BL112 BLB112 WL32 VDD VSS bitcell_6t
XC32_113 BL113 BLB113 WL32 VDD VSS bitcell_6t
XC32_114 BL114 BLB114 WL32 VDD VSS bitcell_6t
XC32_115 BL115 BLB115 WL32 VDD VSS bitcell_6t
XC32_116 BL116 BLB116 WL32 VDD VSS bitcell_6t
XC32_117 BL117 BLB117 WL32 VDD VSS bitcell_6t
XC32_118 BL118 BLB118 WL32 VDD VSS bitcell_6t
XC32_119 BL119 BLB119 WL32 VDD VSS bitcell_6t
XC32_120 BL120 BLB120 WL32 VDD VSS bitcell_6t
XC32_121 BL121 BLB121 WL32 VDD VSS bitcell_6t
XC32_122 BL122 BLB122 WL32 VDD VSS bitcell_6t
XC32_123 BL123 BLB123 WL32 VDD VSS bitcell_6t
XC32_124 BL124 BLB124 WL32 VDD VSS bitcell_6t
XC32_125 BL125 BLB125 WL32 VDD VSS bitcell_6t
XC32_126 BL126 BLB126 WL32 VDD VSS bitcell_6t
XC32_127 BL127 BLB127 WL32 VDD VSS bitcell_6t
XC33_0 BL0 BLB0 WL33 VDD VSS bitcell_6t
XC33_1 BL1 BLB1 WL33 VDD VSS bitcell_6t
XC33_2 BL2 BLB2 WL33 VDD VSS bitcell_6t
XC33_3 BL3 BLB3 WL33 VDD VSS bitcell_6t
XC33_4 BL4 BLB4 WL33 VDD VSS bitcell_6t
XC33_5 BL5 BLB5 WL33 VDD VSS bitcell_6t
XC33_6 BL6 BLB6 WL33 VDD VSS bitcell_6t
XC33_7 BL7 BLB7 WL33 VDD VSS bitcell_6t
XC33_8 BL8 BLB8 WL33 VDD VSS bitcell_6t
XC33_9 BL9 BLB9 WL33 VDD VSS bitcell_6t
XC33_10 BL10 BLB10 WL33 VDD VSS bitcell_6t
XC33_11 BL11 BLB11 WL33 VDD VSS bitcell_6t
XC33_12 BL12 BLB12 WL33 VDD VSS bitcell_6t
XC33_13 BL13 BLB13 WL33 VDD VSS bitcell_6t
XC33_14 BL14 BLB14 WL33 VDD VSS bitcell_6t
XC33_15 BL15 BLB15 WL33 VDD VSS bitcell_6t
XC33_16 BL16 BLB16 WL33 VDD VSS bitcell_6t
XC33_17 BL17 BLB17 WL33 VDD VSS bitcell_6t
XC33_18 BL18 BLB18 WL33 VDD VSS bitcell_6t
XC33_19 BL19 BLB19 WL33 VDD VSS bitcell_6t
XC33_20 BL20 BLB20 WL33 VDD VSS bitcell_6t
XC33_21 BL21 BLB21 WL33 VDD VSS bitcell_6t
XC33_22 BL22 BLB22 WL33 VDD VSS bitcell_6t
XC33_23 BL23 BLB23 WL33 VDD VSS bitcell_6t
XC33_24 BL24 BLB24 WL33 VDD VSS bitcell_6t
XC33_25 BL25 BLB25 WL33 VDD VSS bitcell_6t
XC33_26 BL26 BLB26 WL33 VDD VSS bitcell_6t
XC33_27 BL27 BLB27 WL33 VDD VSS bitcell_6t
XC33_28 BL28 BLB28 WL33 VDD VSS bitcell_6t
XC33_29 BL29 BLB29 WL33 VDD VSS bitcell_6t
XC33_30 BL30 BLB30 WL33 VDD VSS bitcell_6t
XC33_31 BL31 BLB31 WL33 VDD VSS bitcell_6t
XC33_32 BL32 BLB32 WL33 VDD VSS bitcell_6t
XC33_33 BL33 BLB33 WL33 VDD VSS bitcell_6t
XC33_34 BL34 BLB34 WL33 VDD VSS bitcell_6t
XC33_35 BL35 BLB35 WL33 VDD VSS bitcell_6t
XC33_36 BL36 BLB36 WL33 VDD VSS bitcell_6t
XC33_37 BL37 BLB37 WL33 VDD VSS bitcell_6t
XC33_38 BL38 BLB38 WL33 VDD VSS bitcell_6t
XC33_39 BL39 BLB39 WL33 VDD VSS bitcell_6t
XC33_40 BL40 BLB40 WL33 VDD VSS bitcell_6t
XC33_41 BL41 BLB41 WL33 VDD VSS bitcell_6t
XC33_42 BL42 BLB42 WL33 VDD VSS bitcell_6t
XC33_43 BL43 BLB43 WL33 VDD VSS bitcell_6t
XC33_44 BL44 BLB44 WL33 VDD VSS bitcell_6t
XC33_45 BL45 BLB45 WL33 VDD VSS bitcell_6t
XC33_46 BL46 BLB46 WL33 VDD VSS bitcell_6t
XC33_47 BL47 BLB47 WL33 VDD VSS bitcell_6t
XC33_48 BL48 BLB48 WL33 VDD VSS bitcell_6t
XC33_49 BL49 BLB49 WL33 VDD VSS bitcell_6t
XC33_50 BL50 BLB50 WL33 VDD VSS bitcell_6t
XC33_51 BL51 BLB51 WL33 VDD VSS bitcell_6t
XC33_52 BL52 BLB52 WL33 VDD VSS bitcell_6t
XC33_53 BL53 BLB53 WL33 VDD VSS bitcell_6t
XC33_54 BL54 BLB54 WL33 VDD VSS bitcell_6t
XC33_55 BL55 BLB55 WL33 VDD VSS bitcell_6t
XC33_56 BL56 BLB56 WL33 VDD VSS bitcell_6t
XC33_57 BL57 BLB57 WL33 VDD VSS bitcell_6t
XC33_58 BL58 BLB58 WL33 VDD VSS bitcell_6t
XC33_59 BL59 BLB59 WL33 VDD VSS bitcell_6t
XC33_60 BL60 BLB60 WL33 VDD VSS bitcell_6t
XC33_61 BL61 BLB61 WL33 VDD VSS bitcell_6t
XC33_62 BL62 BLB62 WL33 VDD VSS bitcell_6t
XC33_63 BL63 BLB63 WL33 VDD VSS bitcell_6t
XC33_64 BL64 BLB64 WL33 VDD VSS bitcell_6t
XC33_65 BL65 BLB65 WL33 VDD VSS bitcell_6t
XC33_66 BL66 BLB66 WL33 VDD VSS bitcell_6t
XC33_67 BL67 BLB67 WL33 VDD VSS bitcell_6t
XC33_68 BL68 BLB68 WL33 VDD VSS bitcell_6t
XC33_69 BL69 BLB69 WL33 VDD VSS bitcell_6t
XC33_70 BL70 BLB70 WL33 VDD VSS bitcell_6t
XC33_71 BL71 BLB71 WL33 VDD VSS bitcell_6t
XC33_72 BL72 BLB72 WL33 VDD VSS bitcell_6t
XC33_73 BL73 BLB73 WL33 VDD VSS bitcell_6t
XC33_74 BL74 BLB74 WL33 VDD VSS bitcell_6t
XC33_75 BL75 BLB75 WL33 VDD VSS bitcell_6t
XC33_76 BL76 BLB76 WL33 VDD VSS bitcell_6t
XC33_77 BL77 BLB77 WL33 VDD VSS bitcell_6t
XC33_78 BL78 BLB78 WL33 VDD VSS bitcell_6t
XC33_79 BL79 BLB79 WL33 VDD VSS bitcell_6t
XC33_80 BL80 BLB80 WL33 VDD VSS bitcell_6t
XC33_81 BL81 BLB81 WL33 VDD VSS bitcell_6t
XC33_82 BL82 BLB82 WL33 VDD VSS bitcell_6t
XC33_83 BL83 BLB83 WL33 VDD VSS bitcell_6t
XC33_84 BL84 BLB84 WL33 VDD VSS bitcell_6t
XC33_85 BL85 BLB85 WL33 VDD VSS bitcell_6t
XC33_86 BL86 BLB86 WL33 VDD VSS bitcell_6t
XC33_87 BL87 BLB87 WL33 VDD VSS bitcell_6t
XC33_88 BL88 BLB88 WL33 VDD VSS bitcell_6t
XC33_89 BL89 BLB89 WL33 VDD VSS bitcell_6t
XC33_90 BL90 BLB90 WL33 VDD VSS bitcell_6t
XC33_91 BL91 BLB91 WL33 VDD VSS bitcell_6t
XC33_92 BL92 BLB92 WL33 VDD VSS bitcell_6t
XC33_93 BL93 BLB93 WL33 VDD VSS bitcell_6t
XC33_94 BL94 BLB94 WL33 VDD VSS bitcell_6t
XC33_95 BL95 BLB95 WL33 VDD VSS bitcell_6t
XC33_96 BL96 BLB96 WL33 VDD VSS bitcell_6t
XC33_97 BL97 BLB97 WL33 VDD VSS bitcell_6t
XC33_98 BL98 BLB98 WL33 VDD VSS bitcell_6t
XC33_99 BL99 BLB99 WL33 VDD VSS bitcell_6t
XC33_100 BL100 BLB100 WL33 VDD VSS bitcell_6t
XC33_101 BL101 BLB101 WL33 VDD VSS bitcell_6t
XC33_102 BL102 BLB102 WL33 VDD VSS bitcell_6t
XC33_103 BL103 BLB103 WL33 VDD VSS bitcell_6t
XC33_104 BL104 BLB104 WL33 VDD VSS bitcell_6t
XC33_105 BL105 BLB105 WL33 VDD VSS bitcell_6t
XC33_106 BL106 BLB106 WL33 VDD VSS bitcell_6t
XC33_107 BL107 BLB107 WL33 VDD VSS bitcell_6t
XC33_108 BL108 BLB108 WL33 VDD VSS bitcell_6t
XC33_109 BL109 BLB109 WL33 VDD VSS bitcell_6t
XC33_110 BL110 BLB110 WL33 VDD VSS bitcell_6t
XC33_111 BL111 BLB111 WL33 VDD VSS bitcell_6t
XC33_112 BL112 BLB112 WL33 VDD VSS bitcell_6t
XC33_113 BL113 BLB113 WL33 VDD VSS bitcell_6t
XC33_114 BL114 BLB114 WL33 VDD VSS bitcell_6t
XC33_115 BL115 BLB115 WL33 VDD VSS bitcell_6t
XC33_116 BL116 BLB116 WL33 VDD VSS bitcell_6t
XC33_117 BL117 BLB117 WL33 VDD VSS bitcell_6t
XC33_118 BL118 BLB118 WL33 VDD VSS bitcell_6t
XC33_119 BL119 BLB119 WL33 VDD VSS bitcell_6t
XC33_120 BL120 BLB120 WL33 VDD VSS bitcell_6t
XC33_121 BL121 BLB121 WL33 VDD VSS bitcell_6t
XC33_122 BL122 BLB122 WL33 VDD VSS bitcell_6t
XC33_123 BL123 BLB123 WL33 VDD VSS bitcell_6t
XC33_124 BL124 BLB124 WL33 VDD VSS bitcell_6t
XC33_125 BL125 BLB125 WL33 VDD VSS bitcell_6t
XC33_126 BL126 BLB126 WL33 VDD VSS bitcell_6t
XC33_127 BL127 BLB127 WL33 VDD VSS bitcell_6t
XC34_0 BL0 BLB0 WL34 VDD VSS bitcell_6t
XC34_1 BL1 BLB1 WL34 VDD VSS bitcell_6t
XC34_2 BL2 BLB2 WL34 VDD VSS bitcell_6t
XC34_3 BL3 BLB3 WL34 VDD VSS bitcell_6t
XC34_4 BL4 BLB4 WL34 VDD VSS bitcell_6t
XC34_5 BL5 BLB5 WL34 VDD VSS bitcell_6t
XC34_6 BL6 BLB6 WL34 VDD VSS bitcell_6t
XC34_7 BL7 BLB7 WL34 VDD VSS bitcell_6t
XC34_8 BL8 BLB8 WL34 VDD VSS bitcell_6t
XC34_9 BL9 BLB9 WL34 VDD VSS bitcell_6t
XC34_10 BL10 BLB10 WL34 VDD VSS bitcell_6t
XC34_11 BL11 BLB11 WL34 VDD VSS bitcell_6t
XC34_12 BL12 BLB12 WL34 VDD VSS bitcell_6t
XC34_13 BL13 BLB13 WL34 VDD VSS bitcell_6t
XC34_14 BL14 BLB14 WL34 VDD VSS bitcell_6t
XC34_15 BL15 BLB15 WL34 VDD VSS bitcell_6t
XC34_16 BL16 BLB16 WL34 VDD VSS bitcell_6t
XC34_17 BL17 BLB17 WL34 VDD VSS bitcell_6t
XC34_18 BL18 BLB18 WL34 VDD VSS bitcell_6t
XC34_19 BL19 BLB19 WL34 VDD VSS bitcell_6t
XC34_20 BL20 BLB20 WL34 VDD VSS bitcell_6t
XC34_21 BL21 BLB21 WL34 VDD VSS bitcell_6t
XC34_22 BL22 BLB22 WL34 VDD VSS bitcell_6t
XC34_23 BL23 BLB23 WL34 VDD VSS bitcell_6t
XC34_24 BL24 BLB24 WL34 VDD VSS bitcell_6t
XC34_25 BL25 BLB25 WL34 VDD VSS bitcell_6t
XC34_26 BL26 BLB26 WL34 VDD VSS bitcell_6t
XC34_27 BL27 BLB27 WL34 VDD VSS bitcell_6t
XC34_28 BL28 BLB28 WL34 VDD VSS bitcell_6t
XC34_29 BL29 BLB29 WL34 VDD VSS bitcell_6t
XC34_30 BL30 BLB30 WL34 VDD VSS bitcell_6t
XC34_31 BL31 BLB31 WL34 VDD VSS bitcell_6t
XC34_32 BL32 BLB32 WL34 VDD VSS bitcell_6t
XC34_33 BL33 BLB33 WL34 VDD VSS bitcell_6t
XC34_34 BL34 BLB34 WL34 VDD VSS bitcell_6t
XC34_35 BL35 BLB35 WL34 VDD VSS bitcell_6t
XC34_36 BL36 BLB36 WL34 VDD VSS bitcell_6t
XC34_37 BL37 BLB37 WL34 VDD VSS bitcell_6t
XC34_38 BL38 BLB38 WL34 VDD VSS bitcell_6t
XC34_39 BL39 BLB39 WL34 VDD VSS bitcell_6t
XC34_40 BL40 BLB40 WL34 VDD VSS bitcell_6t
XC34_41 BL41 BLB41 WL34 VDD VSS bitcell_6t
XC34_42 BL42 BLB42 WL34 VDD VSS bitcell_6t
XC34_43 BL43 BLB43 WL34 VDD VSS bitcell_6t
XC34_44 BL44 BLB44 WL34 VDD VSS bitcell_6t
XC34_45 BL45 BLB45 WL34 VDD VSS bitcell_6t
XC34_46 BL46 BLB46 WL34 VDD VSS bitcell_6t
XC34_47 BL47 BLB47 WL34 VDD VSS bitcell_6t
XC34_48 BL48 BLB48 WL34 VDD VSS bitcell_6t
XC34_49 BL49 BLB49 WL34 VDD VSS bitcell_6t
XC34_50 BL50 BLB50 WL34 VDD VSS bitcell_6t
XC34_51 BL51 BLB51 WL34 VDD VSS bitcell_6t
XC34_52 BL52 BLB52 WL34 VDD VSS bitcell_6t
XC34_53 BL53 BLB53 WL34 VDD VSS bitcell_6t
XC34_54 BL54 BLB54 WL34 VDD VSS bitcell_6t
XC34_55 BL55 BLB55 WL34 VDD VSS bitcell_6t
XC34_56 BL56 BLB56 WL34 VDD VSS bitcell_6t
XC34_57 BL57 BLB57 WL34 VDD VSS bitcell_6t
XC34_58 BL58 BLB58 WL34 VDD VSS bitcell_6t
XC34_59 BL59 BLB59 WL34 VDD VSS bitcell_6t
XC34_60 BL60 BLB60 WL34 VDD VSS bitcell_6t
XC34_61 BL61 BLB61 WL34 VDD VSS bitcell_6t
XC34_62 BL62 BLB62 WL34 VDD VSS bitcell_6t
XC34_63 BL63 BLB63 WL34 VDD VSS bitcell_6t
XC34_64 BL64 BLB64 WL34 VDD VSS bitcell_6t
XC34_65 BL65 BLB65 WL34 VDD VSS bitcell_6t
XC34_66 BL66 BLB66 WL34 VDD VSS bitcell_6t
XC34_67 BL67 BLB67 WL34 VDD VSS bitcell_6t
XC34_68 BL68 BLB68 WL34 VDD VSS bitcell_6t
XC34_69 BL69 BLB69 WL34 VDD VSS bitcell_6t
XC34_70 BL70 BLB70 WL34 VDD VSS bitcell_6t
XC34_71 BL71 BLB71 WL34 VDD VSS bitcell_6t
XC34_72 BL72 BLB72 WL34 VDD VSS bitcell_6t
XC34_73 BL73 BLB73 WL34 VDD VSS bitcell_6t
XC34_74 BL74 BLB74 WL34 VDD VSS bitcell_6t
XC34_75 BL75 BLB75 WL34 VDD VSS bitcell_6t
XC34_76 BL76 BLB76 WL34 VDD VSS bitcell_6t
XC34_77 BL77 BLB77 WL34 VDD VSS bitcell_6t
XC34_78 BL78 BLB78 WL34 VDD VSS bitcell_6t
XC34_79 BL79 BLB79 WL34 VDD VSS bitcell_6t
XC34_80 BL80 BLB80 WL34 VDD VSS bitcell_6t
XC34_81 BL81 BLB81 WL34 VDD VSS bitcell_6t
XC34_82 BL82 BLB82 WL34 VDD VSS bitcell_6t
XC34_83 BL83 BLB83 WL34 VDD VSS bitcell_6t
XC34_84 BL84 BLB84 WL34 VDD VSS bitcell_6t
XC34_85 BL85 BLB85 WL34 VDD VSS bitcell_6t
XC34_86 BL86 BLB86 WL34 VDD VSS bitcell_6t
XC34_87 BL87 BLB87 WL34 VDD VSS bitcell_6t
XC34_88 BL88 BLB88 WL34 VDD VSS bitcell_6t
XC34_89 BL89 BLB89 WL34 VDD VSS bitcell_6t
XC34_90 BL90 BLB90 WL34 VDD VSS bitcell_6t
XC34_91 BL91 BLB91 WL34 VDD VSS bitcell_6t
XC34_92 BL92 BLB92 WL34 VDD VSS bitcell_6t
XC34_93 BL93 BLB93 WL34 VDD VSS bitcell_6t
XC34_94 BL94 BLB94 WL34 VDD VSS bitcell_6t
XC34_95 BL95 BLB95 WL34 VDD VSS bitcell_6t
XC34_96 BL96 BLB96 WL34 VDD VSS bitcell_6t
XC34_97 BL97 BLB97 WL34 VDD VSS bitcell_6t
XC34_98 BL98 BLB98 WL34 VDD VSS bitcell_6t
XC34_99 BL99 BLB99 WL34 VDD VSS bitcell_6t
XC34_100 BL100 BLB100 WL34 VDD VSS bitcell_6t
XC34_101 BL101 BLB101 WL34 VDD VSS bitcell_6t
XC34_102 BL102 BLB102 WL34 VDD VSS bitcell_6t
XC34_103 BL103 BLB103 WL34 VDD VSS bitcell_6t
XC34_104 BL104 BLB104 WL34 VDD VSS bitcell_6t
XC34_105 BL105 BLB105 WL34 VDD VSS bitcell_6t
XC34_106 BL106 BLB106 WL34 VDD VSS bitcell_6t
XC34_107 BL107 BLB107 WL34 VDD VSS bitcell_6t
XC34_108 BL108 BLB108 WL34 VDD VSS bitcell_6t
XC34_109 BL109 BLB109 WL34 VDD VSS bitcell_6t
XC34_110 BL110 BLB110 WL34 VDD VSS bitcell_6t
XC34_111 BL111 BLB111 WL34 VDD VSS bitcell_6t
XC34_112 BL112 BLB112 WL34 VDD VSS bitcell_6t
XC34_113 BL113 BLB113 WL34 VDD VSS bitcell_6t
XC34_114 BL114 BLB114 WL34 VDD VSS bitcell_6t
XC34_115 BL115 BLB115 WL34 VDD VSS bitcell_6t
XC34_116 BL116 BLB116 WL34 VDD VSS bitcell_6t
XC34_117 BL117 BLB117 WL34 VDD VSS bitcell_6t
XC34_118 BL118 BLB118 WL34 VDD VSS bitcell_6t
XC34_119 BL119 BLB119 WL34 VDD VSS bitcell_6t
XC34_120 BL120 BLB120 WL34 VDD VSS bitcell_6t
XC34_121 BL121 BLB121 WL34 VDD VSS bitcell_6t
XC34_122 BL122 BLB122 WL34 VDD VSS bitcell_6t
XC34_123 BL123 BLB123 WL34 VDD VSS bitcell_6t
XC34_124 BL124 BLB124 WL34 VDD VSS bitcell_6t
XC34_125 BL125 BLB125 WL34 VDD VSS bitcell_6t
XC34_126 BL126 BLB126 WL34 VDD VSS bitcell_6t
XC34_127 BL127 BLB127 WL34 VDD VSS bitcell_6t
XC35_0 BL0 BLB0 WL35 VDD VSS bitcell_6t
XC35_1 BL1 BLB1 WL35 VDD VSS bitcell_6t
XC35_2 BL2 BLB2 WL35 VDD VSS bitcell_6t
XC35_3 BL3 BLB3 WL35 VDD VSS bitcell_6t
XC35_4 BL4 BLB4 WL35 VDD VSS bitcell_6t
XC35_5 BL5 BLB5 WL35 VDD VSS bitcell_6t
XC35_6 BL6 BLB6 WL35 VDD VSS bitcell_6t
XC35_7 BL7 BLB7 WL35 VDD VSS bitcell_6t
XC35_8 BL8 BLB8 WL35 VDD VSS bitcell_6t
XC35_9 BL9 BLB9 WL35 VDD VSS bitcell_6t
XC35_10 BL10 BLB10 WL35 VDD VSS bitcell_6t
XC35_11 BL11 BLB11 WL35 VDD VSS bitcell_6t
XC35_12 BL12 BLB12 WL35 VDD VSS bitcell_6t
XC35_13 BL13 BLB13 WL35 VDD VSS bitcell_6t
XC35_14 BL14 BLB14 WL35 VDD VSS bitcell_6t
XC35_15 BL15 BLB15 WL35 VDD VSS bitcell_6t
XC35_16 BL16 BLB16 WL35 VDD VSS bitcell_6t
XC35_17 BL17 BLB17 WL35 VDD VSS bitcell_6t
XC35_18 BL18 BLB18 WL35 VDD VSS bitcell_6t
XC35_19 BL19 BLB19 WL35 VDD VSS bitcell_6t
XC35_20 BL20 BLB20 WL35 VDD VSS bitcell_6t
XC35_21 BL21 BLB21 WL35 VDD VSS bitcell_6t
XC35_22 BL22 BLB22 WL35 VDD VSS bitcell_6t
XC35_23 BL23 BLB23 WL35 VDD VSS bitcell_6t
XC35_24 BL24 BLB24 WL35 VDD VSS bitcell_6t
XC35_25 BL25 BLB25 WL35 VDD VSS bitcell_6t
XC35_26 BL26 BLB26 WL35 VDD VSS bitcell_6t
XC35_27 BL27 BLB27 WL35 VDD VSS bitcell_6t
XC35_28 BL28 BLB28 WL35 VDD VSS bitcell_6t
XC35_29 BL29 BLB29 WL35 VDD VSS bitcell_6t
XC35_30 BL30 BLB30 WL35 VDD VSS bitcell_6t
XC35_31 BL31 BLB31 WL35 VDD VSS bitcell_6t
XC35_32 BL32 BLB32 WL35 VDD VSS bitcell_6t
XC35_33 BL33 BLB33 WL35 VDD VSS bitcell_6t
XC35_34 BL34 BLB34 WL35 VDD VSS bitcell_6t
XC35_35 BL35 BLB35 WL35 VDD VSS bitcell_6t
XC35_36 BL36 BLB36 WL35 VDD VSS bitcell_6t
XC35_37 BL37 BLB37 WL35 VDD VSS bitcell_6t
XC35_38 BL38 BLB38 WL35 VDD VSS bitcell_6t
XC35_39 BL39 BLB39 WL35 VDD VSS bitcell_6t
XC35_40 BL40 BLB40 WL35 VDD VSS bitcell_6t
XC35_41 BL41 BLB41 WL35 VDD VSS bitcell_6t
XC35_42 BL42 BLB42 WL35 VDD VSS bitcell_6t
XC35_43 BL43 BLB43 WL35 VDD VSS bitcell_6t
XC35_44 BL44 BLB44 WL35 VDD VSS bitcell_6t
XC35_45 BL45 BLB45 WL35 VDD VSS bitcell_6t
XC35_46 BL46 BLB46 WL35 VDD VSS bitcell_6t
XC35_47 BL47 BLB47 WL35 VDD VSS bitcell_6t
XC35_48 BL48 BLB48 WL35 VDD VSS bitcell_6t
XC35_49 BL49 BLB49 WL35 VDD VSS bitcell_6t
XC35_50 BL50 BLB50 WL35 VDD VSS bitcell_6t
XC35_51 BL51 BLB51 WL35 VDD VSS bitcell_6t
XC35_52 BL52 BLB52 WL35 VDD VSS bitcell_6t
XC35_53 BL53 BLB53 WL35 VDD VSS bitcell_6t
XC35_54 BL54 BLB54 WL35 VDD VSS bitcell_6t
XC35_55 BL55 BLB55 WL35 VDD VSS bitcell_6t
XC35_56 BL56 BLB56 WL35 VDD VSS bitcell_6t
XC35_57 BL57 BLB57 WL35 VDD VSS bitcell_6t
XC35_58 BL58 BLB58 WL35 VDD VSS bitcell_6t
XC35_59 BL59 BLB59 WL35 VDD VSS bitcell_6t
XC35_60 BL60 BLB60 WL35 VDD VSS bitcell_6t
XC35_61 BL61 BLB61 WL35 VDD VSS bitcell_6t
XC35_62 BL62 BLB62 WL35 VDD VSS bitcell_6t
XC35_63 BL63 BLB63 WL35 VDD VSS bitcell_6t
XC35_64 BL64 BLB64 WL35 VDD VSS bitcell_6t
XC35_65 BL65 BLB65 WL35 VDD VSS bitcell_6t
XC35_66 BL66 BLB66 WL35 VDD VSS bitcell_6t
XC35_67 BL67 BLB67 WL35 VDD VSS bitcell_6t
XC35_68 BL68 BLB68 WL35 VDD VSS bitcell_6t
XC35_69 BL69 BLB69 WL35 VDD VSS bitcell_6t
XC35_70 BL70 BLB70 WL35 VDD VSS bitcell_6t
XC35_71 BL71 BLB71 WL35 VDD VSS bitcell_6t
XC35_72 BL72 BLB72 WL35 VDD VSS bitcell_6t
XC35_73 BL73 BLB73 WL35 VDD VSS bitcell_6t
XC35_74 BL74 BLB74 WL35 VDD VSS bitcell_6t
XC35_75 BL75 BLB75 WL35 VDD VSS bitcell_6t
XC35_76 BL76 BLB76 WL35 VDD VSS bitcell_6t
XC35_77 BL77 BLB77 WL35 VDD VSS bitcell_6t
XC35_78 BL78 BLB78 WL35 VDD VSS bitcell_6t
XC35_79 BL79 BLB79 WL35 VDD VSS bitcell_6t
XC35_80 BL80 BLB80 WL35 VDD VSS bitcell_6t
XC35_81 BL81 BLB81 WL35 VDD VSS bitcell_6t
XC35_82 BL82 BLB82 WL35 VDD VSS bitcell_6t
XC35_83 BL83 BLB83 WL35 VDD VSS bitcell_6t
XC35_84 BL84 BLB84 WL35 VDD VSS bitcell_6t
XC35_85 BL85 BLB85 WL35 VDD VSS bitcell_6t
XC35_86 BL86 BLB86 WL35 VDD VSS bitcell_6t
XC35_87 BL87 BLB87 WL35 VDD VSS bitcell_6t
XC35_88 BL88 BLB88 WL35 VDD VSS bitcell_6t
XC35_89 BL89 BLB89 WL35 VDD VSS bitcell_6t
XC35_90 BL90 BLB90 WL35 VDD VSS bitcell_6t
XC35_91 BL91 BLB91 WL35 VDD VSS bitcell_6t
XC35_92 BL92 BLB92 WL35 VDD VSS bitcell_6t
XC35_93 BL93 BLB93 WL35 VDD VSS bitcell_6t
XC35_94 BL94 BLB94 WL35 VDD VSS bitcell_6t
XC35_95 BL95 BLB95 WL35 VDD VSS bitcell_6t
XC35_96 BL96 BLB96 WL35 VDD VSS bitcell_6t
XC35_97 BL97 BLB97 WL35 VDD VSS bitcell_6t
XC35_98 BL98 BLB98 WL35 VDD VSS bitcell_6t
XC35_99 BL99 BLB99 WL35 VDD VSS bitcell_6t
XC35_100 BL100 BLB100 WL35 VDD VSS bitcell_6t
XC35_101 BL101 BLB101 WL35 VDD VSS bitcell_6t
XC35_102 BL102 BLB102 WL35 VDD VSS bitcell_6t
XC35_103 BL103 BLB103 WL35 VDD VSS bitcell_6t
XC35_104 BL104 BLB104 WL35 VDD VSS bitcell_6t
XC35_105 BL105 BLB105 WL35 VDD VSS bitcell_6t
XC35_106 BL106 BLB106 WL35 VDD VSS bitcell_6t
XC35_107 BL107 BLB107 WL35 VDD VSS bitcell_6t
XC35_108 BL108 BLB108 WL35 VDD VSS bitcell_6t
XC35_109 BL109 BLB109 WL35 VDD VSS bitcell_6t
XC35_110 BL110 BLB110 WL35 VDD VSS bitcell_6t
XC35_111 BL111 BLB111 WL35 VDD VSS bitcell_6t
XC35_112 BL112 BLB112 WL35 VDD VSS bitcell_6t
XC35_113 BL113 BLB113 WL35 VDD VSS bitcell_6t
XC35_114 BL114 BLB114 WL35 VDD VSS bitcell_6t
XC35_115 BL115 BLB115 WL35 VDD VSS bitcell_6t
XC35_116 BL116 BLB116 WL35 VDD VSS bitcell_6t
XC35_117 BL117 BLB117 WL35 VDD VSS bitcell_6t
XC35_118 BL118 BLB118 WL35 VDD VSS bitcell_6t
XC35_119 BL119 BLB119 WL35 VDD VSS bitcell_6t
XC35_120 BL120 BLB120 WL35 VDD VSS bitcell_6t
XC35_121 BL121 BLB121 WL35 VDD VSS bitcell_6t
XC35_122 BL122 BLB122 WL35 VDD VSS bitcell_6t
XC35_123 BL123 BLB123 WL35 VDD VSS bitcell_6t
XC35_124 BL124 BLB124 WL35 VDD VSS bitcell_6t
XC35_125 BL125 BLB125 WL35 VDD VSS bitcell_6t
XC35_126 BL126 BLB126 WL35 VDD VSS bitcell_6t
XC35_127 BL127 BLB127 WL35 VDD VSS bitcell_6t
XC36_0 BL0 BLB0 WL36 VDD VSS bitcell_6t
XC36_1 BL1 BLB1 WL36 VDD VSS bitcell_6t
XC36_2 BL2 BLB2 WL36 VDD VSS bitcell_6t
XC36_3 BL3 BLB3 WL36 VDD VSS bitcell_6t
XC36_4 BL4 BLB4 WL36 VDD VSS bitcell_6t
XC36_5 BL5 BLB5 WL36 VDD VSS bitcell_6t
XC36_6 BL6 BLB6 WL36 VDD VSS bitcell_6t
XC36_7 BL7 BLB7 WL36 VDD VSS bitcell_6t
XC36_8 BL8 BLB8 WL36 VDD VSS bitcell_6t
XC36_9 BL9 BLB9 WL36 VDD VSS bitcell_6t
XC36_10 BL10 BLB10 WL36 VDD VSS bitcell_6t
XC36_11 BL11 BLB11 WL36 VDD VSS bitcell_6t
XC36_12 BL12 BLB12 WL36 VDD VSS bitcell_6t
XC36_13 BL13 BLB13 WL36 VDD VSS bitcell_6t
XC36_14 BL14 BLB14 WL36 VDD VSS bitcell_6t
XC36_15 BL15 BLB15 WL36 VDD VSS bitcell_6t
XC36_16 BL16 BLB16 WL36 VDD VSS bitcell_6t
XC36_17 BL17 BLB17 WL36 VDD VSS bitcell_6t
XC36_18 BL18 BLB18 WL36 VDD VSS bitcell_6t
XC36_19 BL19 BLB19 WL36 VDD VSS bitcell_6t
XC36_20 BL20 BLB20 WL36 VDD VSS bitcell_6t
XC36_21 BL21 BLB21 WL36 VDD VSS bitcell_6t
XC36_22 BL22 BLB22 WL36 VDD VSS bitcell_6t
XC36_23 BL23 BLB23 WL36 VDD VSS bitcell_6t
XC36_24 BL24 BLB24 WL36 VDD VSS bitcell_6t
XC36_25 BL25 BLB25 WL36 VDD VSS bitcell_6t
XC36_26 BL26 BLB26 WL36 VDD VSS bitcell_6t
XC36_27 BL27 BLB27 WL36 VDD VSS bitcell_6t
XC36_28 BL28 BLB28 WL36 VDD VSS bitcell_6t
XC36_29 BL29 BLB29 WL36 VDD VSS bitcell_6t
XC36_30 BL30 BLB30 WL36 VDD VSS bitcell_6t
XC36_31 BL31 BLB31 WL36 VDD VSS bitcell_6t
XC36_32 BL32 BLB32 WL36 VDD VSS bitcell_6t
XC36_33 BL33 BLB33 WL36 VDD VSS bitcell_6t
XC36_34 BL34 BLB34 WL36 VDD VSS bitcell_6t
XC36_35 BL35 BLB35 WL36 VDD VSS bitcell_6t
XC36_36 BL36 BLB36 WL36 VDD VSS bitcell_6t
XC36_37 BL37 BLB37 WL36 VDD VSS bitcell_6t
XC36_38 BL38 BLB38 WL36 VDD VSS bitcell_6t
XC36_39 BL39 BLB39 WL36 VDD VSS bitcell_6t
XC36_40 BL40 BLB40 WL36 VDD VSS bitcell_6t
XC36_41 BL41 BLB41 WL36 VDD VSS bitcell_6t
XC36_42 BL42 BLB42 WL36 VDD VSS bitcell_6t
XC36_43 BL43 BLB43 WL36 VDD VSS bitcell_6t
XC36_44 BL44 BLB44 WL36 VDD VSS bitcell_6t
XC36_45 BL45 BLB45 WL36 VDD VSS bitcell_6t
XC36_46 BL46 BLB46 WL36 VDD VSS bitcell_6t
XC36_47 BL47 BLB47 WL36 VDD VSS bitcell_6t
XC36_48 BL48 BLB48 WL36 VDD VSS bitcell_6t
XC36_49 BL49 BLB49 WL36 VDD VSS bitcell_6t
XC36_50 BL50 BLB50 WL36 VDD VSS bitcell_6t
XC36_51 BL51 BLB51 WL36 VDD VSS bitcell_6t
XC36_52 BL52 BLB52 WL36 VDD VSS bitcell_6t
XC36_53 BL53 BLB53 WL36 VDD VSS bitcell_6t
XC36_54 BL54 BLB54 WL36 VDD VSS bitcell_6t
XC36_55 BL55 BLB55 WL36 VDD VSS bitcell_6t
XC36_56 BL56 BLB56 WL36 VDD VSS bitcell_6t
XC36_57 BL57 BLB57 WL36 VDD VSS bitcell_6t
XC36_58 BL58 BLB58 WL36 VDD VSS bitcell_6t
XC36_59 BL59 BLB59 WL36 VDD VSS bitcell_6t
XC36_60 BL60 BLB60 WL36 VDD VSS bitcell_6t
XC36_61 BL61 BLB61 WL36 VDD VSS bitcell_6t
XC36_62 BL62 BLB62 WL36 VDD VSS bitcell_6t
XC36_63 BL63 BLB63 WL36 VDD VSS bitcell_6t
XC36_64 BL64 BLB64 WL36 VDD VSS bitcell_6t
XC36_65 BL65 BLB65 WL36 VDD VSS bitcell_6t
XC36_66 BL66 BLB66 WL36 VDD VSS bitcell_6t
XC36_67 BL67 BLB67 WL36 VDD VSS bitcell_6t
XC36_68 BL68 BLB68 WL36 VDD VSS bitcell_6t
XC36_69 BL69 BLB69 WL36 VDD VSS bitcell_6t
XC36_70 BL70 BLB70 WL36 VDD VSS bitcell_6t
XC36_71 BL71 BLB71 WL36 VDD VSS bitcell_6t
XC36_72 BL72 BLB72 WL36 VDD VSS bitcell_6t
XC36_73 BL73 BLB73 WL36 VDD VSS bitcell_6t
XC36_74 BL74 BLB74 WL36 VDD VSS bitcell_6t
XC36_75 BL75 BLB75 WL36 VDD VSS bitcell_6t
XC36_76 BL76 BLB76 WL36 VDD VSS bitcell_6t
XC36_77 BL77 BLB77 WL36 VDD VSS bitcell_6t
XC36_78 BL78 BLB78 WL36 VDD VSS bitcell_6t
XC36_79 BL79 BLB79 WL36 VDD VSS bitcell_6t
XC36_80 BL80 BLB80 WL36 VDD VSS bitcell_6t
XC36_81 BL81 BLB81 WL36 VDD VSS bitcell_6t
XC36_82 BL82 BLB82 WL36 VDD VSS bitcell_6t
XC36_83 BL83 BLB83 WL36 VDD VSS bitcell_6t
XC36_84 BL84 BLB84 WL36 VDD VSS bitcell_6t
XC36_85 BL85 BLB85 WL36 VDD VSS bitcell_6t
XC36_86 BL86 BLB86 WL36 VDD VSS bitcell_6t
XC36_87 BL87 BLB87 WL36 VDD VSS bitcell_6t
XC36_88 BL88 BLB88 WL36 VDD VSS bitcell_6t
XC36_89 BL89 BLB89 WL36 VDD VSS bitcell_6t
XC36_90 BL90 BLB90 WL36 VDD VSS bitcell_6t
XC36_91 BL91 BLB91 WL36 VDD VSS bitcell_6t
XC36_92 BL92 BLB92 WL36 VDD VSS bitcell_6t
XC36_93 BL93 BLB93 WL36 VDD VSS bitcell_6t
XC36_94 BL94 BLB94 WL36 VDD VSS bitcell_6t
XC36_95 BL95 BLB95 WL36 VDD VSS bitcell_6t
XC36_96 BL96 BLB96 WL36 VDD VSS bitcell_6t
XC36_97 BL97 BLB97 WL36 VDD VSS bitcell_6t
XC36_98 BL98 BLB98 WL36 VDD VSS bitcell_6t
XC36_99 BL99 BLB99 WL36 VDD VSS bitcell_6t
XC36_100 BL100 BLB100 WL36 VDD VSS bitcell_6t
XC36_101 BL101 BLB101 WL36 VDD VSS bitcell_6t
XC36_102 BL102 BLB102 WL36 VDD VSS bitcell_6t
XC36_103 BL103 BLB103 WL36 VDD VSS bitcell_6t
XC36_104 BL104 BLB104 WL36 VDD VSS bitcell_6t
XC36_105 BL105 BLB105 WL36 VDD VSS bitcell_6t
XC36_106 BL106 BLB106 WL36 VDD VSS bitcell_6t
XC36_107 BL107 BLB107 WL36 VDD VSS bitcell_6t
XC36_108 BL108 BLB108 WL36 VDD VSS bitcell_6t
XC36_109 BL109 BLB109 WL36 VDD VSS bitcell_6t
XC36_110 BL110 BLB110 WL36 VDD VSS bitcell_6t
XC36_111 BL111 BLB111 WL36 VDD VSS bitcell_6t
XC36_112 BL112 BLB112 WL36 VDD VSS bitcell_6t
XC36_113 BL113 BLB113 WL36 VDD VSS bitcell_6t
XC36_114 BL114 BLB114 WL36 VDD VSS bitcell_6t
XC36_115 BL115 BLB115 WL36 VDD VSS bitcell_6t
XC36_116 BL116 BLB116 WL36 VDD VSS bitcell_6t
XC36_117 BL117 BLB117 WL36 VDD VSS bitcell_6t
XC36_118 BL118 BLB118 WL36 VDD VSS bitcell_6t
XC36_119 BL119 BLB119 WL36 VDD VSS bitcell_6t
XC36_120 BL120 BLB120 WL36 VDD VSS bitcell_6t
XC36_121 BL121 BLB121 WL36 VDD VSS bitcell_6t
XC36_122 BL122 BLB122 WL36 VDD VSS bitcell_6t
XC36_123 BL123 BLB123 WL36 VDD VSS bitcell_6t
XC36_124 BL124 BLB124 WL36 VDD VSS bitcell_6t
XC36_125 BL125 BLB125 WL36 VDD VSS bitcell_6t
XC36_126 BL126 BLB126 WL36 VDD VSS bitcell_6t
XC36_127 BL127 BLB127 WL36 VDD VSS bitcell_6t
XC37_0 BL0 BLB0 WL37 VDD VSS bitcell_6t
XC37_1 BL1 BLB1 WL37 VDD VSS bitcell_6t
XC37_2 BL2 BLB2 WL37 VDD VSS bitcell_6t
XC37_3 BL3 BLB3 WL37 VDD VSS bitcell_6t
XC37_4 BL4 BLB4 WL37 VDD VSS bitcell_6t
XC37_5 BL5 BLB5 WL37 VDD VSS bitcell_6t
XC37_6 BL6 BLB6 WL37 VDD VSS bitcell_6t
XC37_7 BL7 BLB7 WL37 VDD VSS bitcell_6t
XC37_8 BL8 BLB8 WL37 VDD VSS bitcell_6t
XC37_9 BL9 BLB9 WL37 VDD VSS bitcell_6t
XC37_10 BL10 BLB10 WL37 VDD VSS bitcell_6t
XC37_11 BL11 BLB11 WL37 VDD VSS bitcell_6t
XC37_12 BL12 BLB12 WL37 VDD VSS bitcell_6t
XC37_13 BL13 BLB13 WL37 VDD VSS bitcell_6t
XC37_14 BL14 BLB14 WL37 VDD VSS bitcell_6t
XC37_15 BL15 BLB15 WL37 VDD VSS bitcell_6t
XC37_16 BL16 BLB16 WL37 VDD VSS bitcell_6t
XC37_17 BL17 BLB17 WL37 VDD VSS bitcell_6t
XC37_18 BL18 BLB18 WL37 VDD VSS bitcell_6t
XC37_19 BL19 BLB19 WL37 VDD VSS bitcell_6t
XC37_20 BL20 BLB20 WL37 VDD VSS bitcell_6t
XC37_21 BL21 BLB21 WL37 VDD VSS bitcell_6t
XC37_22 BL22 BLB22 WL37 VDD VSS bitcell_6t
XC37_23 BL23 BLB23 WL37 VDD VSS bitcell_6t
XC37_24 BL24 BLB24 WL37 VDD VSS bitcell_6t
XC37_25 BL25 BLB25 WL37 VDD VSS bitcell_6t
XC37_26 BL26 BLB26 WL37 VDD VSS bitcell_6t
XC37_27 BL27 BLB27 WL37 VDD VSS bitcell_6t
XC37_28 BL28 BLB28 WL37 VDD VSS bitcell_6t
XC37_29 BL29 BLB29 WL37 VDD VSS bitcell_6t
XC37_30 BL30 BLB30 WL37 VDD VSS bitcell_6t
XC37_31 BL31 BLB31 WL37 VDD VSS bitcell_6t
XC37_32 BL32 BLB32 WL37 VDD VSS bitcell_6t
XC37_33 BL33 BLB33 WL37 VDD VSS bitcell_6t
XC37_34 BL34 BLB34 WL37 VDD VSS bitcell_6t
XC37_35 BL35 BLB35 WL37 VDD VSS bitcell_6t
XC37_36 BL36 BLB36 WL37 VDD VSS bitcell_6t
XC37_37 BL37 BLB37 WL37 VDD VSS bitcell_6t
XC37_38 BL38 BLB38 WL37 VDD VSS bitcell_6t
XC37_39 BL39 BLB39 WL37 VDD VSS bitcell_6t
XC37_40 BL40 BLB40 WL37 VDD VSS bitcell_6t
XC37_41 BL41 BLB41 WL37 VDD VSS bitcell_6t
XC37_42 BL42 BLB42 WL37 VDD VSS bitcell_6t
XC37_43 BL43 BLB43 WL37 VDD VSS bitcell_6t
XC37_44 BL44 BLB44 WL37 VDD VSS bitcell_6t
XC37_45 BL45 BLB45 WL37 VDD VSS bitcell_6t
XC37_46 BL46 BLB46 WL37 VDD VSS bitcell_6t
XC37_47 BL47 BLB47 WL37 VDD VSS bitcell_6t
XC37_48 BL48 BLB48 WL37 VDD VSS bitcell_6t
XC37_49 BL49 BLB49 WL37 VDD VSS bitcell_6t
XC37_50 BL50 BLB50 WL37 VDD VSS bitcell_6t
XC37_51 BL51 BLB51 WL37 VDD VSS bitcell_6t
XC37_52 BL52 BLB52 WL37 VDD VSS bitcell_6t
XC37_53 BL53 BLB53 WL37 VDD VSS bitcell_6t
XC37_54 BL54 BLB54 WL37 VDD VSS bitcell_6t
XC37_55 BL55 BLB55 WL37 VDD VSS bitcell_6t
XC37_56 BL56 BLB56 WL37 VDD VSS bitcell_6t
XC37_57 BL57 BLB57 WL37 VDD VSS bitcell_6t
XC37_58 BL58 BLB58 WL37 VDD VSS bitcell_6t
XC37_59 BL59 BLB59 WL37 VDD VSS bitcell_6t
XC37_60 BL60 BLB60 WL37 VDD VSS bitcell_6t
XC37_61 BL61 BLB61 WL37 VDD VSS bitcell_6t
XC37_62 BL62 BLB62 WL37 VDD VSS bitcell_6t
XC37_63 BL63 BLB63 WL37 VDD VSS bitcell_6t
XC37_64 BL64 BLB64 WL37 VDD VSS bitcell_6t
XC37_65 BL65 BLB65 WL37 VDD VSS bitcell_6t
XC37_66 BL66 BLB66 WL37 VDD VSS bitcell_6t
XC37_67 BL67 BLB67 WL37 VDD VSS bitcell_6t
XC37_68 BL68 BLB68 WL37 VDD VSS bitcell_6t
XC37_69 BL69 BLB69 WL37 VDD VSS bitcell_6t
XC37_70 BL70 BLB70 WL37 VDD VSS bitcell_6t
XC37_71 BL71 BLB71 WL37 VDD VSS bitcell_6t
XC37_72 BL72 BLB72 WL37 VDD VSS bitcell_6t
XC37_73 BL73 BLB73 WL37 VDD VSS bitcell_6t
XC37_74 BL74 BLB74 WL37 VDD VSS bitcell_6t
XC37_75 BL75 BLB75 WL37 VDD VSS bitcell_6t
XC37_76 BL76 BLB76 WL37 VDD VSS bitcell_6t
XC37_77 BL77 BLB77 WL37 VDD VSS bitcell_6t
XC37_78 BL78 BLB78 WL37 VDD VSS bitcell_6t
XC37_79 BL79 BLB79 WL37 VDD VSS bitcell_6t
XC37_80 BL80 BLB80 WL37 VDD VSS bitcell_6t
XC37_81 BL81 BLB81 WL37 VDD VSS bitcell_6t
XC37_82 BL82 BLB82 WL37 VDD VSS bitcell_6t
XC37_83 BL83 BLB83 WL37 VDD VSS bitcell_6t
XC37_84 BL84 BLB84 WL37 VDD VSS bitcell_6t
XC37_85 BL85 BLB85 WL37 VDD VSS bitcell_6t
XC37_86 BL86 BLB86 WL37 VDD VSS bitcell_6t
XC37_87 BL87 BLB87 WL37 VDD VSS bitcell_6t
XC37_88 BL88 BLB88 WL37 VDD VSS bitcell_6t
XC37_89 BL89 BLB89 WL37 VDD VSS bitcell_6t
XC37_90 BL90 BLB90 WL37 VDD VSS bitcell_6t
XC37_91 BL91 BLB91 WL37 VDD VSS bitcell_6t
XC37_92 BL92 BLB92 WL37 VDD VSS bitcell_6t
XC37_93 BL93 BLB93 WL37 VDD VSS bitcell_6t
XC37_94 BL94 BLB94 WL37 VDD VSS bitcell_6t
XC37_95 BL95 BLB95 WL37 VDD VSS bitcell_6t
XC37_96 BL96 BLB96 WL37 VDD VSS bitcell_6t
XC37_97 BL97 BLB97 WL37 VDD VSS bitcell_6t
XC37_98 BL98 BLB98 WL37 VDD VSS bitcell_6t
XC37_99 BL99 BLB99 WL37 VDD VSS bitcell_6t
XC37_100 BL100 BLB100 WL37 VDD VSS bitcell_6t
XC37_101 BL101 BLB101 WL37 VDD VSS bitcell_6t
XC37_102 BL102 BLB102 WL37 VDD VSS bitcell_6t
XC37_103 BL103 BLB103 WL37 VDD VSS bitcell_6t
XC37_104 BL104 BLB104 WL37 VDD VSS bitcell_6t
XC37_105 BL105 BLB105 WL37 VDD VSS bitcell_6t
XC37_106 BL106 BLB106 WL37 VDD VSS bitcell_6t
XC37_107 BL107 BLB107 WL37 VDD VSS bitcell_6t
XC37_108 BL108 BLB108 WL37 VDD VSS bitcell_6t
XC37_109 BL109 BLB109 WL37 VDD VSS bitcell_6t
XC37_110 BL110 BLB110 WL37 VDD VSS bitcell_6t
XC37_111 BL111 BLB111 WL37 VDD VSS bitcell_6t
XC37_112 BL112 BLB112 WL37 VDD VSS bitcell_6t
XC37_113 BL113 BLB113 WL37 VDD VSS bitcell_6t
XC37_114 BL114 BLB114 WL37 VDD VSS bitcell_6t
XC37_115 BL115 BLB115 WL37 VDD VSS bitcell_6t
XC37_116 BL116 BLB116 WL37 VDD VSS bitcell_6t
XC37_117 BL117 BLB117 WL37 VDD VSS bitcell_6t
XC37_118 BL118 BLB118 WL37 VDD VSS bitcell_6t
XC37_119 BL119 BLB119 WL37 VDD VSS bitcell_6t
XC37_120 BL120 BLB120 WL37 VDD VSS bitcell_6t
XC37_121 BL121 BLB121 WL37 VDD VSS bitcell_6t
XC37_122 BL122 BLB122 WL37 VDD VSS bitcell_6t
XC37_123 BL123 BLB123 WL37 VDD VSS bitcell_6t
XC37_124 BL124 BLB124 WL37 VDD VSS bitcell_6t
XC37_125 BL125 BLB125 WL37 VDD VSS bitcell_6t
XC37_126 BL126 BLB126 WL37 VDD VSS bitcell_6t
XC37_127 BL127 BLB127 WL37 VDD VSS bitcell_6t
XC38_0 BL0 BLB0 WL38 VDD VSS bitcell_6t
XC38_1 BL1 BLB1 WL38 VDD VSS bitcell_6t
XC38_2 BL2 BLB2 WL38 VDD VSS bitcell_6t
XC38_3 BL3 BLB3 WL38 VDD VSS bitcell_6t
XC38_4 BL4 BLB4 WL38 VDD VSS bitcell_6t
XC38_5 BL5 BLB5 WL38 VDD VSS bitcell_6t
XC38_6 BL6 BLB6 WL38 VDD VSS bitcell_6t
XC38_7 BL7 BLB7 WL38 VDD VSS bitcell_6t
XC38_8 BL8 BLB8 WL38 VDD VSS bitcell_6t
XC38_9 BL9 BLB9 WL38 VDD VSS bitcell_6t
XC38_10 BL10 BLB10 WL38 VDD VSS bitcell_6t
XC38_11 BL11 BLB11 WL38 VDD VSS bitcell_6t
XC38_12 BL12 BLB12 WL38 VDD VSS bitcell_6t
XC38_13 BL13 BLB13 WL38 VDD VSS bitcell_6t
XC38_14 BL14 BLB14 WL38 VDD VSS bitcell_6t
XC38_15 BL15 BLB15 WL38 VDD VSS bitcell_6t
XC38_16 BL16 BLB16 WL38 VDD VSS bitcell_6t
XC38_17 BL17 BLB17 WL38 VDD VSS bitcell_6t
XC38_18 BL18 BLB18 WL38 VDD VSS bitcell_6t
XC38_19 BL19 BLB19 WL38 VDD VSS bitcell_6t
XC38_20 BL20 BLB20 WL38 VDD VSS bitcell_6t
XC38_21 BL21 BLB21 WL38 VDD VSS bitcell_6t
XC38_22 BL22 BLB22 WL38 VDD VSS bitcell_6t
XC38_23 BL23 BLB23 WL38 VDD VSS bitcell_6t
XC38_24 BL24 BLB24 WL38 VDD VSS bitcell_6t
XC38_25 BL25 BLB25 WL38 VDD VSS bitcell_6t
XC38_26 BL26 BLB26 WL38 VDD VSS bitcell_6t
XC38_27 BL27 BLB27 WL38 VDD VSS bitcell_6t
XC38_28 BL28 BLB28 WL38 VDD VSS bitcell_6t
XC38_29 BL29 BLB29 WL38 VDD VSS bitcell_6t
XC38_30 BL30 BLB30 WL38 VDD VSS bitcell_6t
XC38_31 BL31 BLB31 WL38 VDD VSS bitcell_6t
XC38_32 BL32 BLB32 WL38 VDD VSS bitcell_6t
XC38_33 BL33 BLB33 WL38 VDD VSS bitcell_6t
XC38_34 BL34 BLB34 WL38 VDD VSS bitcell_6t
XC38_35 BL35 BLB35 WL38 VDD VSS bitcell_6t
XC38_36 BL36 BLB36 WL38 VDD VSS bitcell_6t
XC38_37 BL37 BLB37 WL38 VDD VSS bitcell_6t
XC38_38 BL38 BLB38 WL38 VDD VSS bitcell_6t
XC38_39 BL39 BLB39 WL38 VDD VSS bitcell_6t
XC38_40 BL40 BLB40 WL38 VDD VSS bitcell_6t
XC38_41 BL41 BLB41 WL38 VDD VSS bitcell_6t
XC38_42 BL42 BLB42 WL38 VDD VSS bitcell_6t
XC38_43 BL43 BLB43 WL38 VDD VSS bitcell_6t
XC38_44 BL44 BLB44 WL38 VDD VSS bitcell_6t
XC38_45 BL45 BLB45 WL38 VDD VSS bitcell_6t
XC38_46 BL46 BLB46 WL38 VDD VSS bitcell_6t
XC38_47 BL47 BLB47 WL38 VDD VSS bitcell_6t
XC38_48 BL48 BLB48 WL38 VDD VSS bitcell_6t
XC38_49 BL49 BLB49 WL38 VDD VSS bitcell_6t
XC38_50 BL50 BLB50 WL38 VDD VSS bitcell_6t
XC38_51 BL51 BLB51 WL38 VDD VSS bitcell_6t
XC38_52 BL52 BLB52 WL38 VDD VSS bitcell_6t
XC38_53 BL53 BLB53 WL38 VDD VSS bitcell_6t
XC38_54 BL54 BLB54 WL38 VDD VSS bitcell_6t
XC38_55 BL55 BLB55 WL38 VDD VSS bitcell_6t
XC38_56 BL56 BLB56 WL38 VDD VSS bitcell_6t
XC38_57 BL57 BLB57 WL38 VDD VSS bitcell_6t
XC38_58 BL58 BLB58 WL38 VDD VSS bitcell_6t
XC38_59 BL59 BLB59 WL38 VDD VSS bitcell_6t
XC38_60 BL60 BLB60 WL38 VDD VSS bitcell_6t
XC38_61 BL61 BLB61 WL38 VDD VSS bitcell_6t
XC38_62 BL62 BLB62 WL38 VDD VSS bitcell_6t
XC38_63 BL63 BLB63 WL38 VDD VSS bitcell_6t
XC38_64 BL64 BLB64 WL38 VDD VSS bitcell_6t
XC38_65 BL65 BLB65 WL38 VDD VSS bitcell_6t
XC38_66 BL66 BLB66 WL38 VDD VSS bitcell_6t
XC38_67 BL67 BLB67 WL38 VDD VSS bitcell_6t
XC38_68 BL68 BLB68 WL38 VDD VSS bitcell_6t
XC38_69 BL69 BLB69 WL38 VDD VSS bitcell_6t
XC38_70 BL70 BLB70 WL38 VDD VSS bitcell_6t
XC38_71 BL71 BLB71 WL38 VDD VSS bitcell_6t
XC38_72 BL72 BLB72 WL38 VDD VSS bitcell_6t
XC38_73 BL73 BLB73 WL38 VDD VSS bitcell_6t
XC38_74 BL74 BLB74 WL38 VDD VSS bitcell_6t
XC38_75 BL75 BLB75 WL38 VDD VSS bitcell_6t
XC38_76 BL76 BLB76 WL38 VDD VSS bitcell_6t
XC38_77 BL77 BLB77 WL38 VDD VSS bitcell_6t
XC38_78 BL78 BLB78 WL38 VDD VSS bitcell_6t
XC38_79 BL79 BLB79 WL38 VDD VSS bitcell_6t
XC38_80 BL80 BLB80 WL38 VDD VSS bitcell_6t
XC38_81 BL81 BLB81 WL38 VDD VSS bitcell_6t
XC38_82 BL82 BLB82 WL38 VDD VSS bitcell_6t
XC38_83 BL83 BLB83 WL38 VDD VSS bitcell_6t
XC38_84 BL84 BLB84 WL38 VDD VSS bitcell_6t
XC38_85 BL85 BLB85 WL38 VDD VSS bitcell_6t
XC38_86 BL86 BLB86 WL38 VDD VSS bitcell_6t
XC38_87 BL87 BLB87 WL38 VDD VSS bitcell_6t
XC38_88 BL88 BLB88 WL38 VDD VSS bitcell_6t
XC38_89 BL89 BLB89 WL38 VDD VSS bitcell_6t
XC38_90 BL90 BLB90 WL38 VDD VSS bitcell_6t
XC38_91 BL91 BLB91 WL38 VDD VSS bitcell_6t
XC38_92 BL92 BLB92 WL38 VDD VSS bitcell_6t
XC38_93 BL93 BLB93 WL38 VDD VSS bitcell_6t
XC38_94 BL94 BLB94 WL38 VDD VSS bitcell_6t
XC38_95 BL95 BLB95 WL38 VDD VSS bitcell_6t
XC38_96 BL96 BLB96 WL38 VDD VSS bitcell_6t
XC38_97 BL97 BLB97 WL38 VDD VSS bitcell_6t
XC38_98 BL98 BLB98 WL38 VDD VSS bitcell_6t
XC38_99 BL99 BLB99 WL38 VDD VSS bitcell_6t
XC38_100 BL100 BLB100 WL38 VDD VSS bitcell_6t
XC38_101 BL101 BLB101 WL38 VDD VSS bitcell_6t
XC38_102 BL102 BLB102 WL38 VDD VSS bitcell_6t
XC38_103 BL103 BLB103 WL38 VDD VSS bitcell_6t
XC38_104 BL104 BLB104 WL38 VDD VSS bitcell_6t
XC38_105 BL105 BLB105 WL38 VDD VSS bitcell_6t
XC38_106 BL106 BLB106 WL38 VDD VSS bitcell_6t
XC38_107 BL107 BLB107 WL38 VDD VSS bitcell_6t
XC38_108 BL108 BLB108 WL38 VDD VSS bitcell_6t
XC38_109 BL109 BLB109 WL38 VDD VSS bitcell_6t
XC38_110 BL110 BLB110 WL38 VDD VSS bitcell_6t
XC38_111 BL111 BLB111 WL38 VDD VSS bitcell_6t
XC38_112 BL112 BLB112 WL38 VDD VSS bitcell_6t
XC38_113 BL113 BLB113 WL38 VDD VSS bitcell_6t
XC38_114 BL114 BLB114 WL38 VDD VSS bitcell_6t
XC38_115 BL115 BLB115 WL38 VDD VSS bitcell_6t
XC38_116 BL116 BLB116 WL38 VDD VSS bitcell_6t
XC38_117 BL117 BLB117 WL38 VDD VSS bitcell_6t
XC38_118 BL118 BLB118 WL38 VDD VSS bitcell_6t
XC38_119 BL119 BLB119 WL38 VDD VSS bitcell_6t
XC38_120 BL120 BLB120 WL38 VDD VSS bitcell_6t
XC38_121 BL121 BLB121 WL38 VDD VSS bitcell_6t
XC38_122 BL122 BLB122 WL38 VDD VSS bitcell_6t
XC38_123 BL123 BLB123 WL38 VDD VSS bitcell_6t
XC38_124 BL124 BLB124 WL38 VDD VSS bitcell_6t
XC38_125 BL125 BLB125 WL38 VDD VSS bitcell_6t
XC38_126 BL126 BLB126 WL38 VDD VSS bitcell_6t
XC38_127 BL127 BLB127 WL38 VDD VSS bitcell_6t
XC39_0 BL0 BLB0 WL39 VDD VSS bitcell_6t
XC39_1 BL1 BLB1 WL39 VDD VSS bitcell_6t
XC39_2 BL2 BLB2 WL39 VDD VSS bitcell_6t
XC39_3 BL3 BLB3 WL39 VDD VSS bitcell_6t
XC39_4 BL4 BLB4 WL39 VDD VSS bitcell_6t
XC39_5 BL5 BLB5 WL39 VDD VSS bitcell_6t
XC39_6 BL6 BLB6 WL39 VDD VSS bitcell_6t
XC39_7 BL7 BLB7 WL39 VDD VSS bitcell_6t
XC39_8 BL8 BLB8 WL39 VDD VSS bitcell_6t
XC39_9 BL9 BLB9 WL39 VDD VSS bitcell_6t
XC39_10 BL10 BLB10 WL39 VDD VSS bitcell_6t
XC39_11 BL11 BLB11 WL39 VDD VSS bitcell_6t
XC39_12 BL12 BLB12 WL39 VDD VSS bitcell_6t
XC39_13 BL13 BLB13 WL39 VDD VSS bitcell_6t
XC39_14 BL14 BLB14 WL39 VDD VSS bitcell_6t
XC39_15 BL15 BLB15 WL39 VDD VSS bitcell_6t
XC39_16 BL16 BLB16 WL39 VDD VSS bitcell_6t
XC39_17 BL17 BLB17 WL39 VDD VSS bitcell_6t
XC39_18 BL18 BLB18 WL39 VDD VSS bitcell_6t
XC39_19 BL19 BLB19 WL39 VDD VSS bitcell_6t
XC39_20 BL20 BLB20 WL39 VDD VSS bitcell_6t
XC39_21 BL21 BLB21 WL39 VDD VSS bitcell_6t
XC39_22 BL22 BLB22 WL39 VDD VSS bitcell_6t
XC39_23 BL23 BLB23 WL39 VDD VSS bitcell_6t
XC39_24 BL24 BLB24 WL39 VDD VSS bitcell_6t
XC39_25 BL25 BLB25 WL39 VDD VSS bitcell_6t
XC39_26 BL26 BLB26 WL39 VDD VSS bitcell_6t
XC39_27 BL27 BLB27 WL39 VDD VSS bitcell_6t
XC39_28 BL28 BLB28 WL39 VDD VSS bitcell_6t
XC39_29 BL29 BLB29 WL39 VDD VSS bitcell_6t
XC39_30 BL30 BLB30 WL39 VDD VSS bitcell_6t
XC39_31 BL31 BLB31 WL39 VDD VSS bitcell_6t
XC39_32 BL32 BLB32 WL39 VDD VSS bitcell_6t
XC39_33 BL33 BLB33 WL39 VDD VSS bitcell_6t
XC39_34 BL34 BLB34 WL39 VDD VSS bitcell_6t
XC39_35 BL35 BLB35 WL39 VDD VSS bitcell_6t
XC39_36 BL36 BLB36 WL39 VDD VSS bitcell_6t
XC39_37 BL37 BLB37 WL39 VDD VSS bitcell_6t
XC39_38 BL38 BLB38 WL39 VDD VSS bitcell_6t
XC39_39 BL39 BLB39 WL39 VDD VSS bitcell_6t
XC39_40 BL40 BLB40 WL39 VDD VSS bitcell_6t
XC39_41 BL41 BLB41 WL39 VDD VSS bitcell_6t
XC39_42 BL42 BLB42 WL39 VDD VSS bitcell_6t
XC39_43 BL43 BLB43 WL39 VDD VSS bitcell_6t
XC39_44 BL44 BLB44 WL39 VDD VSS bitcell_6t
XC39_45 BL45 BLB45 WL39 VDD VSS bitcell_6t
XC39_46 BL46 BLB46 WL39 VDD VSS bitcell_6t
XC39_47 BL47 BLB47 WL39 VDD VSS bitcell_6t
XC39_48 BL48 BLB48 WL39 VDD VSS bitcell_6t
XC39_49 BL49 BLB49 WL39 VDD VSS bitcell_6t
XC39_50 BL50 BLB50 WL39 VDD VSS bitcell_6t
XC39_51 BL51 BLB51 WL39 VDD VSS bitcell_6t
XC39_52 BL52 BLB52 WL39 VDD VSS bitcell_6t
XC39_53 BL53 BLB53 WL39 VDD VSS bitcell_6t
XC39_54 BL54 BLB54 WL39 VDD VSS bitcell_6t
XC39_55 BL55 BLB55 WL39 VDD VSS bitcell_6t
XC39_56 BL56 BLB56 WL39 VDD VSS bitcell_6t
XC39_57 BL57 BLB57 WL39 VDD VSS bitcell_6t
XC39_58 BL58 BLB58 WL39 VDD VSS bitcell_6t
XC39_59 BL59 BLB59 WL39 VDD VSS bitcell_6t
XC39_60 BL60 BLB60 WL39 VDD VSS bitcell_6t
XC39_61 BL61 BLB61 WL39 VDD VSS bitcell_6t
XC39_62 BL62 BLB62 WL39 VDD VSS bitcell_6t
XC39_63 BL63 BLB63 WL39 VDD VSS bitcell_6t
XC39_64 BL64 BLB64 WL39 VDD VSS bitcell_6t
XC39_65 BL65 BLB65 WL39 VDD VSS bitcell_6t
XC39_66 BL66 BLB66 WL39 VDD VSS bitcell_6t
XC39_67 BL67 BLB67 WL39 VDD VSS bitcell_6t
XC39_68 BL68 BLB68 WL39 VDD VSS bitcell_6t
XC39_69 BL69 BLB69 WL39 VDD VSS bitcell_6t
XC39_70 BL70 BLB70 WL39 VDD VSS bitcell_6t
XC39_71 BL71 BLB71 WL39 VDD VSS bitcell_6t
XC39_72 BL72 BLB72 WL39 VDD VSS bitcell_6t
XC39_73 BL73 BLB73 WL39 VDD VSS bitcell_6t
XC39_74 BL74 BLB74 WL39 VDD VSS bitcell_6t
XC39_75 BL75 BLB75 WL39 VDD VSS bitcell_6t
XC39_76 BL76 BLB76 WL39 VDD VSS bitcell_6t
XC39_77 BL77 BLB77 WL39 VDD VSS bitcell_6t
XC39_78 BL78 BLB78 WL39 VDD VSS bitcell_6t
XC39_79 BL79 BLB79 WL39 VDD VSS bitcell_6t
XC39_80 BL80 BLB80 WL39 VDD VSS bitcell_6t
XC39_81 BL81 BLB81 WL39 VDD VSS bitcell_6t
XC39_82 BL82 BLB82 WL39 VDD VSS bitcell_6t
XC39_83 BL83 BLB83 WL39 VDD VSS bitcell_6t
XC39_84 BL84 BLB84 WL39 VDD VSS bitcell_6t
XC39_85 BL85 BLB85 WL39 VDD VSS bitcell_6t
XC39_86 BL86 BLB86 WL39 VDD VSS bitcell_6t
XC39_87 BL87 BLB87 WL39 VDD VSS bitcell_6t
XC39_88 BL88 BLB88 WL39 VDD VSS bitcell_6t
XC39_89 BL89 BLB89 WL39 VDD VSS bitcell_6t
XC39_90 BL90 BLB90 WL39 VDD VSS bitcell_6t
XC39_91 BL91 BLB91 WL39 VDD VSS bitcell_6t
XC39_92 BL92 BLB92 WL39 VDD VSS bitcell_6t
XC39_93 BL93 BLB93 WL39 VDD VSS bitcell_6t
XC39_94 BL94 BLB94 WL39 VDD VSS bitcell_6t
XC39_95 BL95 BLB95 WL39 VDD VSS bitcell_6t
XC39_96 BL96 BLB96 WL39 VDD VSS bitcell_6t
XC39_97 BL97 BLB97 WL39 VDD VSS bitcell_6t
XC39_98 BL98 BLB98 WL39 VDD VSS bitcell_6t
XC39_99 BL99 BLB99 WL39 VDD VSS bitcell_6t
XC39_100 BL100 BLB100 WL39 VDD VSS bitcell_6t
XC39_101 BL101 BLB101 WL39 VDD VSS bitcell_6t
XC39_102 BL102 BLB102 WL39 VDD VSS bitcell_6t
XC39_103 BL103 BLB103 WL39 VDD VSS bitcell_6t
XC39_104 BL104 BLB104 WL39 VDD VSS bitcell_6t
XC39_105 BL105 BLB105 WL39 VDD VSS bitcell_6t
XC39_106 BL106 BLB106 WL39 VDD VSS bitcell_6t
XC39_107 BL107 BLB107 WL39 VDD VSS bitcell_6t
XC39_108 BL108 BLB108 WL39 VDD VSS bitcell_6t
XC39_109 BL109 BLB109 WL39 VDD VSS bitcell_6t
XC39_110 BL110 BLB110 WL39 VDD VSS bitcell_6t
XC39_111 BL111 BLB111 WL39 VDD VSS bitcell_6t
XC39_112 BL112 BLB112 WL39 VDD VSS bitcell_6t
XC39_113 BL113 BLB113 WL39 VDD VSS bitcell_6t
XC39_114 BL114 BLB114 WL39 VDD VSS bitcell_6t
XC39_115 BL115 BLB115 WL39 VDD VSS bitcell_6t
XC39_116 BL116 BLB116 WL39 VDD VSS bitcell_6t
XC39_117 BL117 BLB117 WL39 VDD VSS bitcell_6t
XC39_118 BL118 BLB118 WL39 VDD VSS bitcell_6t
XC39_119 BL119 BLB119 WL39 VDD VSS bitcell_6t
XC39_120 BL120 BLB120 WL39 VDD VSS bitcell_6t
XC39_121 BL121 BLB121 WL39 VDD VSS bitcell_6t
XC39_122 BL122 BLB122 WL39 VDD VSS bitcell_6t
XC39_123 BL123 BLB123 WL39 VDD VSS bitcell_6t
XC39_124 BL124 BLB124 WL39 VDD VSS bitcell_6t
XC39_125 BL125 BLB125 WL39 VDD VSS bitcell_6t
XC39_126 BL126 BLB126 WL39 VDD VSS bitcell_6t
XC39_127 BL127 BLB127 WL39 VDD VSS bitcell_6t
XC40_0 BL0 BLB0 WL40 VDD VSS bitcell_6t
XC40_1 BL1 BLB1 WL40 VDD VSS bitcell_6t
XC40_2 BL2 BLB2 WL40 VDD VSS bitcell_6t
XC40_3 BL3 BLB3 WL40 VDD VSS bitcell_6t
XC40_4 BL4 BLB4 WL40 VDD VSS bitcell_6t
XC40_5 BL5 BLB5 WL40 VDD VSS bitcell_6t
XC40_6 BL6 BLB6 WL40 VDD VSS bitcell_6t
XC40_7 BL7 BLB7 WL40 VDD VSS bitcell_6t
XC40_8 BL8 BLB8 WL40 VDD VSS bitcell_6t
XC40_9 BL9 BLB9 WL40 VDD VSS bitcell_6t
XC40_10 BL10 BLB10 WL40 VDD VSS bitcell_6t
XC40_11 BL11 BLB11 WL40 VDD VSS bitcell_6t
XC40_12 BL12 BLB12 WL40 VDD VSS bitcell_6t
XC40_13 BL13 BLB13 WL40 VDD VSS bitcell_6t
XC40_14 BL14 BLB14 WL40 VDD VSS bitcell_6t
XC40_15 BL15 BLB15 WL40 VDD VSS bitcell_6t
XC40_16 BL16 BLB16 WL40 VDD VSS bitcell_6t
XC40_17 BL17 BLB17 WL40 VDD VSS bitcell_6t
XC40_18 BL18 BLB18 WL40 VDD VSS bitcell_6t
XC40_19 BL19 BLB19 WL40 VDD VSS bitcell_6t
XC40_20 BL20 BLB20 WL40 VDD VSS bitcell_6t
XC40_21 BL21 BLB21 WL40 VDD VSS bitcell_6t
XC40_22 BL22 BLB22 WL40 VDD VSS bitcell_6t
XC40_23 BL23 BLB23 WL40 VDD VSS bitcell_6t
XC40_24 BL24 BLB24 WL40 VDD VSS bitcell_6t
XC40_25 BL25 BLB25 WL40 VDD VSS bitcell_6t
XC40_26 BL26 BLB26 WL40 VDD VSS bitcell_6t
XC40_27 BL27 BLB27 WL40 VDD VSS bitcell_6t
XC40_28 BL28 BLB28 WL40 VDD VSS bitcell_6t
XC40_29 BL29 BLB29 WL40 VDD VSS bitcell_6t
XC40_30 BL30 BLB30 WL40 VDD VSS bitcell_6t
XC40_31 BL31 BLB31 WL40 VDD VSS bitcell_6t
XC40_32 BL32 BLB32 WL40 VDD VSS bitcell_6t
XC40_33 BL33 BLB33 WL40 VDD VSS bitcell_6t
XC40_34 BL34 BLB34 WL40 VDD VSS bitcell_6t
XC40_35 BL35 BLB35 WL40 VDD VSS bitcell_6t
XC40_36 BL36 BLB36 WL40 VDD VSS bitcell_6t
XC40_37 BL37 BLB37 WL40 VDD VSS bitcell_6t
XC40_38 BL38 BLB38 WL40 VDD VSS bitcell_6t
XC40_39 BL39 BLB39 WL40 VDD VSS bitcell_6t
XC40_40 BL40 BLB40 WL40 VDD VSS bitcell_6t
XC40_41 BL41 BLB41 WL40 VDD VSS bitcell_6t
XC40_42 BL42 BLB42 WL40 VDD VSS bitcell_6t
XC40_43 BL43 BLB43 WL40 VDD VSS bitcell_6t
XC40_44 BL44 BLB44 WL40 VDD VSS bitcell_6t
XC40_45 BL45 BLB45 WL40 VDD VSS bitcell_6t
XC40_46 BL46 BLB46 WL40 VDD VSS bitcell_6t
XC40_47 BL47 BLB47 WL40 VDD VSS bitcell_6t
XC40_48 BL48 BLB48 WL40 VDD VSS bitcell_6t
XC40_49 BL49 BLB49 WL40 VDD VSS bitcell_6t
XC40_50 BL50 BLB50 WL40 VDD VSS bitcell_6t
XC40_51 BL51 BLB51 WL40 VDD VSS bitcell_6t
XC40_52 BL52 BLB52 WL40 VDD VSS bitcell_6t
XC40_53 BL53 BLB53 WL40 VDD VSS bitcell_6t
XC40_54 BL54 BLB54 WL40 VDD VSS bitcell_6t
XC40_55 BL55 BLB55 WL40 VDD VSS bitcell_6t
XC40_56 BL56 BLB56 WL40 VDD VSS bitcell_6t
XC40_57 BL57 BLB57 WL40 VDD VSS bitcell_6t
XC40_58 BL58 BLB58 WL40 VDD VSS bitcell_6t
XC40_59 BL59 BLB59 WL40 VDD VSS bitcell_6t
XC40_60 BL60 BLB60 WL40 VDD VSS bitcell_6t
XC40_61 BL61 BLB61 WL40 VDD VSS bitcell_6t
XC40_62 BL62 BLB62 WL40 VDD VSS bitcell_6t
XC40_63 BL63 BLB63 WL40 VDD VSS bitcell_6t
XC40_64 BL64 BLB64 WL40 VDD VSS bitcell_6t
XC40_65 BL65 BLB65 WL40 VDD VSS bitcell_6t
XC40_66 BL66 BLB66 WL40 VDD VSS bitcell_6t
XC40_67 BL67 BLB67 WL40 VDD VSS bitcell_6t
XC40_68 BL68 BLB68 WL40 VDD VSS bitcell_6t
XC40_69 BL69 BLB69 WL40 VDD VSS bitcell_6t
XC40_70 BL70 BLB70 WL40 VDD VSS bitcell_6t
XC40_71 BL71 BLB71 WL40 VDD VSS bitcell_6t
XC40_72 BL72 BLB72 WL40 VDD VSS bitcell_6t
XC40_73 BL73 BLB73 WL40 VDD VSS bitcell_6t
XC40_74 BL74 BLB74 WL40 VDD VSS bitcell_6t
XC40_75 BL75 BLB75 WL40 VDD VSS bitcell_6t
XC40_76 BL76 BLB76 WL40 VDD VSS bitcell_6t
XC40_77 BL77 BLB77 WL40 VDD VSS bitcell_6t
XC40_78 BL78 BLB78 WL40 VDD VSS bitcell_6t
XC40_79 BL79 BLB79 WL40 VDD VSS bitcell_6t
XC40_80 BL80 BLB80 WL40 VDD VSS bitcell_6t
XC40_81 BL81 BLB81 WL40 VDD VSS bitcell_6t
XC40_82 BL82 BLB82 WL40 VDD VSS bitcell_6t
XC40_83 BL83 BLB83 WL40 VDD VSS bitcell_6t
XC40_84 BL84 BLB84 WL40 VDD VSS bitcell_6t
XC40_85 BL85 BLB85 WL40 VDD VSS bitcell_6t
XC40_86 BL86 BLB86 WL40 VDD VSS bitcell_6t
XC40_87 BL87 BLB87 WL40 VDD VSS bitcell_6t
XC40_88 BL88 BLB88 WL40 VDD VSS bitcell_6t
XC40_89 BL89 BLB89 WL40 VDD VSS bitcell_6t
XC40_90 BL90 BLB90 WL40 VDD VSS bitcell_6t
XC40_91 BL91 BLB91 WL40 VDD VSS bitcell_6t
XC40_92 BL92 BLB92 WL40 VDD VSS bitcell_6t
XC40_93 BL93 BLB93 WL40 VDD VSS bitcell_6t
XC40_94 BL94 BLB94 WL40 VDD VSS bitcell_6t
XC40_95 BL95 BLB95 WL40 VDD VSS bitcell_6t
XC40_96 BL96 BLB96 WL40 VDD VSS bitcell_6t
XC40_97 BL97 BLB97 WL40 VDD VSS bitcell_6t
XC40_98 BL98 BLB98 WL40 VDD VSS bitcell_6t
XC40_99 BL99 BLB99 WL40 VDD VSS bitcell_6t
XC40_100 BL100 BLB100 WL40 VDD VSS bitcell_6t
XC40_101 BL101 BLB101 WL40 VDD VSS bitcell_6t
XC40_102 BL102 BLB102 WL40 VDD VSS bitcell_6t
XC40_103 BL103 BLB103 WL40 VDD VSS bitcell_6t
XC40_104 BL104 BLB104 WL40 VDD VSS bitcell_6t
XC40_105 BL105 BLB105 WL40 VDD VSS bitcell_6t
XC40_106 BL106 BLB106 WL40 VDD VSS bitcell_6t
XC40_107 BL107 BLB107 WL40 VDD VSS bitcell_6t
XC40_108 BL108 BLB108 WL40 VDD VSS bitcell_6t
XC40_109 BL109 BLB109 WL40 VDD VSS bitcell_6t
XC40_110 BL110 BLB110 WL40 VDD VSS bitcell_6t
XC40_111 BL111 BLB111 WL40 VDD VSS bitcell_6t
XC40_112 BL112 BLB112 WL40 VDD VSS bitcell_6t
XC40_113 BL113 BLB113 WL40 VDD VSS bitcell_6t
XC40_114 BL114 BLB114 WL40 VDD VSS bitcell_6t
XC40_115 BL115 BLB115 WL40 VDD VSS bitcell_6t
XC40_116 BL116 BLB116 WL40 VDD VSS bitcell_6t
XC40_117 BL117 BLB117 WL40 VDD VSS bitcell_6t
XC40_118 BL118 BLB118 WL40 VDD VSS bitcell_6t
XC40_119 BL119 BLB119 WL40 VDD VSS bitcell_6t
XC40_120 BL120 BLB120 WL40 VDD VSS bitcell_6t
XC40_121 BL121 BLB121 WL40 VDD VSS bitcell_6t
XC40_122 BL122 BLB122 WL40 VDD VSS bitcell_6t
XC40_123 BL123 BLB123 WL40 VDD VSS bitcell_6t
XC40_124 BL124 BLB124 WL40 VDD VSS bitcell_6t
XC40_125 BL125 BLB125 WL40 VDD VSS bitcell_6t
XC40_126 BL126 BLB126 WL40 VDD VSS bitcell_6t
XC40_127 BL127 BLB127 WL40 VDD VSS bitcell_6t
XC41_0 BL0 BLB0 WL41 VDD VSS bitcell_6t
XC41_1 BL1 BLB1 WL41 VDD VSS bitcell_6t
XC41_2 BL2 BLB2 WL41 VDD VSS bitcell_6t
XC41_3 BL3 BLB3 WL41 VDD VSS bitcell_6t
XC41_4 BL4 BLB4 WL41 VDD VSS bitcell_6t
XC41_5 BL5 BLB5 WL41 VDD VSS bitcell_6t
XC41_6 BL6 BLB6 WL41 VDD VSS bitcell_6t
XC41_7 BL7 BLB7 WL41 VDD VSS bitcell_6t
XC41_8 BL8 BLB8 WL41 VDD VSS bitcell_6t
XC41_9 BL9 BLB9 WL41 VDD VSS bitcell_6t
XC41_10 BL10 BLB10 WL41 VDD VSS bitcell_6t
XC41_11 BL11 BLB11 WL41 VDD VSS bitcell_6t
XC41_12 BL12 BLB12 WL41 VDD VSS bitcell_6t
XC41_13 BL13 BLB13 WL41 VDD VSS bitcell_6t
XC41_14 BL14 BLB14 WL41 VDD VSS bitcell_6t
XC41_15 BL15 BLB15 WL41 VDD VSS bitcell_6t
XC41_16 BL16 BLB16 WL41 VDD VSS bitcell_6t
XC41_17 BL17 BLB17 WL41 VDD VSS bitcell_6t
XC41_18 BL18 BLB18 WL41 VDD VSS bitcell_6t
XC41_19 BL19 BLB19 WL41 VDD VSS bitcell_6t
XC41_20 BL20 BLB20 WL41 VDD VSS bitcell_6t
XC41_21 BL21 BLB21 WL41 VDD VSS bitcell_6t
XC41_22 BL22 BLB22 WL41 VDD VSS bitcell_6t
XC41_23 BL23 BLB23 WL41 VDD VSS bitcell_6t
XC41_24 BL24 BLB24 WL41 VDD VSS bitcell_6t
XC41_25 BL25 BLB25 WL41 VDD VSS bitcell_6t
XC41_26 BL26 BLB26 WL41 VDD VSS bitcell_6t
XC41_27 BL27 BLB27 WL41 VDD VSS bitcell_6t
XC41_28 BL28 BLB28 WL41 VDD VSS bitcell_6t
XC41_29 BL29 BLB29 WL41 VDD VSS bitcell_6t
XC41_30 BL30 BLB30 WL41 VDD VSS bitcell_6t
XC41_31 BL31 BLB31 WL41 VDD VSS bitcell_6t
XC41_32 BL32 BLB32 WL41 VDD VSS bitcell_6t
XC41_33 BL33 BLB33 WL41 VDD VSS bitcell_6t
XC41_34 BL34 BLB34 WL41 VDD VSS bitcell_6t
XC41_35 BL35 BLB35 WL41 VDD VSS bitcell_6t
XC41_36 BL36 BLB36 WL41 VDD VSS bitcell_6t
XC41_37 BL37 BLB37 WL41 VDD VSS bitcell_6t
XC41_38 BL38 BLB38 WL41 VDD VSS bitcell_6t
XC41_39 BL39 BLB39 WL41 VDD VSS bitcell_6t
XC41_40 BL40 BLB40 WL41 VDD VSS bitcell_6t
XC41_41 BL41 BLB41 WL41 VDD VSS bitcell_6t
XC41_42 BL42 BLB42 WL41 VDD VSS bitcell_6t
XC41_43 BL43 BLB43 WL41 VDD VSS bitcell_6t
XC41_44 BL44 BLB44 WL41 VDD VSS bitcell_6t
XC41_45 BL45 BLB45 WL41 VDD VSS bitcell_6t
XC41_46 BL46 BLB46 WL41 VDD VSS bitcell_6t
XC41_47 BL47 BLB47 WL41 VDD VSS bitcell_6t
XC41_48 BL48 BLB48 WL41 VDD VSS bitcell_6t
XC41_49 BL49 BLB49 WL41 VDD VSS bitcell_6t
XC41_50 BL50 BLB50 WL41 VDD VSS bitcell_6t
XC41_51 BL51 BLB51 WL41 VDD VSS bitcell_6t
XC41_52 BL52 BLB52 WL41 VDD VSS bitcell_6t
XC41_53 BL53 BLB53 WL41 VDD VSS bitcell_6t
XC41_54 BL54 BLB54 WL41 VDD VSS bitcell_6t
XC41_55 BL55 BLB55 WL41 VDD VSS bitcell_6t
XC41_56 BL56 BLB56 WL41 VDD VSS bitcell_6t
XC41_57 BL57 BLB57 WL41 VDD VSS bitcell_6t
XC41_58 BL58 BLB58 WL41 VDD VSS bitcell_6t
XC41_59 BL59 BLB59 WL41 VDD VSS bitcell_6t
XC41_60 BL60 BLB60 WL41 VDD VSS bitcell_6t
XC41_61 BL61 BLB61 WL41 VDD VSS bitcell_6t
XC41_62 BL62 BLB62 WL41 VDD VSS bitcell_6t
XC41_63 BL63 BLB63 WL41 VDD VSS bitcell_6t
XC41_64 BL64 BLB64 WL41 VDD VSS bitcell_6t
XC41_65 BL65 BLB65 WL41 VDD VSS bitcell_6t
XC41_66 BL66 BLB66 WL41 VDD VSS bitcell_6t
XC41_67 BL67 BLB67 WL41 VDD VSS bitcell_6t
XC41_68 BL68 BLB68 WL41 VDD VSS bitcell_6t
XC41_69 BL69 BLB69 WL41 VDD VSS bitcell_6t
XC41_70 BL70 BLB70 WL41 VDD VSS bitcell_6t
XC41_71 BL71 BLB71 WL41 VDD VSS bitcell_6t
XC41_72 BL72 BLB72 WL41 VDD VSS bitcell_6t
XC41_73 BL73 BLB73 WL41 VDD VSS bitcell_6t
XC41_74 BL74 BLB74 WL41 VDD VSS bitcell_6t
XC41_75 BL75 BLB75 WL41 VDD VSS bitcell_6t
XC41_76 BL76 BLB76 WL41 VDD VSS bitcell_6t
XC41_77 BL77 BLB77 WL41 VDD VSS bitcell_6t
XC41_78 BL78 BLB78 WL41 VDD VSS bitcell_6t
XC41_79 BL79 BLB79 WL41 VDD VSS bitcell_6t
XC41_80 BL80 BLB80 WL41 VDD VSS bitcell_6t
XC41_81 BL81 BLB81 WL41 VDD VSS bitcell_6t
XC41_82 BL82 BLB82 WL41 VDD VSS bitcell_6t
XC41_83 BL83 BLB83 WL41 VDD VSS bitcell_6t
XC41_84 BL84 BLB84 WL41 VDD VSS bitcell_6t
XC41_85 BL85 BLB85 WL41 VDD VSS bitcell_6t
XC41_86 BL86 BLB86 WL41 VDD VSS bitcell_6t
XC41_87 BL87 BLB87 WL41 VDD VSS bitcell_6t
XC41_88 BL88 BLB88 WL41 VDD VSS bitcell_6t
XC41_89 BL89 BLB89 WL41 VDD VSS bitcell_6t
XC41_90 BL90 BLB90 WL41 VDD VSS bitcell_6t
XC41_91 BL91 BLB91 WL41 VDD VSS bitcell_6t
XC41_92 BL92 BLB92 WL41 VDD VSS bitcell_6t
XC41_93 BL93 BLB93 WL41 VDD VSS bitcell_6t
XC41_94 BL94 BLB94 WL41 VDD VSS bitcell_6t
XC41_95 BL95 BLB95 WL41 VDD VSS bitcell_6t
XC41_96 BL96 BLB96 WL41 VDD VSS bitcell_6t
XC41_97 BL97 BLB97 WL41 VDD VSS bitcell_6t
XC41_98 BL98 BLB98 WL41 VDD VSS bitcell_6t
XC41_99 BL99 BLB99 WL41 VDD VSS bitcell_6t
XC41_100 BL100 BLB100 WL41 VDD VSS bitcell_6t
XC41_101 BL101 BLB101 WL41 VDD VSS bitcell_6t
XC41_102 BL102 BLB102 WL41 VDD VSS bitcell_6t
XC41_103 BL103 BLB103 WL41 VDD VSS bitcell_6t
XC41_104 BL104 BLB104 WL41 VDD VSS bitcell_6t
XC41_105 BL105 BLB105 WL41 VDD VSS bitcell_6t
XC41_106 BL106 BLB106 WL41 VDD VSS bitcell_6t
XC41_107 BL107 BLB107 WL41 VDD VSS bitcell_6t
XC41_108 BL108 BLB108 WL41 VDD VSS bitcell_6t
XC41_109 BL109 BLB109 WL41 VDD VSS bitcell_6t
XC41_110 BL110 BLB110 WL41 VDD VSS bitcell_6t
XC41_111 BL111 BLB111 WL41 VDD VSS bitcell_6t
XC41_112 BL112 BLB112 WL41 VDD VSS bitcell_6t
XC41_113 BL113 BLB113 WL41 VDD VSS bitcell_6t
XC41_114 BL114 BLB114 WL41 VDD VSS bitcell_6t
XC41_115 BL115 BLB115 WL41 VDD VSS bitcell_6t
XC41_116 BL116 BLB116 WL41 VDD VSS bitcell_6t
XC41_117 BL117 BLB117 WL41 VDD VSS bitcell_6t
XC41_118 BL118 BLB118 WL41 VDD VSS bitcell_6t
XC41_119 BL119 BLB119 WL41 VDD VSS bitcell_6t
XC41_120 BL120 BLB120 WL41 VDD VSS bitcell_6t
XC41_121 BL121 BLB121 WL41 VDD VSS bitcell_6t
XC41_122 BL122 BLB122 WL41 VDD VSS bitcell_6t
XC41_123 BL123 BLB123 WL41 VDD VSS bitcell_6t
XC41_124 BL124 BLB124 WL41 VDD VSS bitcell_6t
XC41_125 BL125 BLB125 WL41 VDD VSS bitcell_6t
XC41_126 BL126 BLB126 WL41 VDD VSS bitcell_6t
XC41_127 BL127 BLB127 WL41 VDD VSS bitcell_6t
XC42_0 BL0 BLB0 WL42 VDD VSS bitcell_6t
XC42_1 BL1 BLB1 WL42 VDD VSS bitcell_6t
XC42_2 BL2 BLB2 WL42 VDD VSS bitcell_6t
XC42_3 BL3 BLB3 WL42 VDD VSS bitcell_6t
XC42_4 BL4 BLB4 WL42 VDD VSS bitcell_6t
XC42_5 BL5 BLB5 WL42 VDD VSS bitcell_6t
XC42_6 BL6 BLB6 WL42 VDD VSS bitcell_6t
XC42_7 BL7 BLB7 WL42 VDD VSS bitcell_6t
XC42_8 BL8 BLB8 WL42 VDD VSS bitcell_6t
XC42_9 BL9 BLB9 WL42 VDD VSS bitcell_6t
XC42_10 BL10 BLB10 WL42 VDD VSS bitcell_6t
XC42_11 BL11 BLB11 WL42 VDD VSS bitcell_6t
XC42_12 BL12 BLB12 WL42 VDD VSS bitcell_6t
XC42_13 BL13 BLB13 WL42 VDD VSS bitcell_6t
XC42_14 BL14 BLB14 WL42 VDD VSS bitcell_6t
XC42_15 BL15 BLB15 WL42 VDD VSS bitcell_6t
XC42_16 BL16 BLB16 WL42 VDD VSS bitcell_6t
XC42_17 BL17 BLB17 WL42 VDD VSS bitcell_6t
XC42_18 BL18 BLB18 WL42 VDD VSS bitcell_6t
XC42_19 BL19 BLB19 WL42 VDD VSS bitcell_6t
XC42_20 BL20 BLB20 WL42 VDD VSS bitcell_6t
XC42_21 BL21 BLB21 WL42 VDD VSS bitcell_6t
XC42_22 BL22 BLB22 WL42 VDD VSS bitcell_6t
XC42_23 BL23 BLB23 WL42 VDD VSS bitcell_6t
XC42_24 BL24 BLB24 WL42 VDD VSS bitcell_6t
XC42_25 BL25 BLB25 WL42 VDD VSS bitcell_6t
XC42_26 BL26 BLB26 WL42 VDD VSS bitcell_6t
XC42_27 BL27 BLB27 WL42 VDD VSS bitcell_6t
XC42_28 BL28 BLB28 WL42 VDD VSS bitcell_6t
XC42_29 BL29 BLB29 WL42 VDD VSS bitcell_6t
XC42_30 BL30 BLB30 WL42 VDD VSS bitcell_6t
XC42_31 BL31 BLB31 WL42 VDD VSS bitcell_6t
XC42_32 BL32 BLB32 WL42 VDD VSS bitcell_6t
XC42_33 BL33 BLB33 WL42 VDD VSS bitcell_6t
XC42_34 BL34 BLB34 WL42 VDD VSS bitcell_6t
XC42_35 BL35 BLB35 WL42 VDD VSS bitcell_6t
XC42_36 BL36 BLB36 WL42 VDD VSS bitcell_6t
XC42_37 BL37 BLB37 WL42 VDD VSS bitcell_6t
XC42_38 BL38 BLB38 WL42 VDD VSS bitcell_6t
XC42_39 BL39 BLB39 WL42 VDD VSS bitcell_6t
XC42_40 BL40 BLB40 WL42 VDD VSS bitcell_6t
XC42_41 BL41 BLB41 WL42 VDD VSS bitcell_6t
XC42_42 BL42 BLB42 WL42 VDD VSS bitcell_6t
XC42_43 BL43 BLB43 WL42 VDD VSS bitcell_6t
XC42_44 BL44 BLB44 WL42 VDD VSS bitcell_6t
XC42_45 BL45 BLB45 WL42 VDD VSS bitcell_6t
XC42_46 BL46 BLB46 WL42 VDD VSS bitcell_6t
XC42_47 BL47 BLB47 WL42 VDD VSS bitcell_6t
XC42_48 BL48 BLB48 WL42 VDD VSS bitcell_6t
XC42_49 BL49 BLB49 WL42 VDD VSS bitcell_6t
XC42_50 BL50 BLB50 WL42 VDD VSS bitcell_6t
XC42_51 BL51 BLB51 WL42 VDD VSS bitcell_6t
XC42_52 BL52 BLB52 WL42 VDD VSS bitcell_6t
XC42_53 BL53 BLB53 WL42 VDD VSS bitcell_6t
XC42_54 BL54 BLB54 WL42 VDD VSS bitcell_6t
XC42_55 BL55 BLB55 WL42 VDD VSS bitcell_6t
XC42_56 BL56 BLB56 WL42 VDD VSS bitcell_6t
XC42_57 BL57 BLB57 WL42 VDD VSS bitcell_6t
XC42_58 BL58 BLB58 WL42 VDD VSS bitcell_6t
XC42_59 BL59 BLB59 WL42 VDD VSS bitcell_6t
XC42_60 BL60 BLB60 WL42 VDD VSS bitcell_6t
XC42_61 BL61 BLB61 WL42 VDD VSS bitcell_6t
XC42_62 BL62 BLB62 WL42 VDD VSS bitcell_6t
XC42_63 BL63 BLB63 WL42 VDD VSS bitcell_6t
XC42_64 BL64 BLB64 WL42 VDD VSS bitcell_6t
XC42_65 BL65 BLB65 WL42 VDD VSS bitcell_6t
XC42_66 BL66 BLB66 WL42 VDD VSS bitcell_6t
XC42_67 BL67 BLB67 WL42 VDD VSS bitcell_6t
XC42_68 BL68 BLB68 WL42 VDD VSS bitcell_6t
XC42_69 BL69 BLB69 WL42 VDD VSS bitcell_6t
XC42_70 BL70 BLB70 WL42 VDD VSS bitcell_6t
XC42_71 BL71 BLB71 WL42 VDD VSS bitcell_6t
XC42_72 BL72 BLB72 WL42 VDD VSS bitcell_6t
XC42_73 BL73 BLB73 WL42 VDD VSS bitcell_6t
XC42_74 BL74 BLB74 WL42 VDD VSS bitcell_6t
XC42_75 BL75 BLB75 WL42 VDD VSS bitcell_6t
XC42_76 BL76 BLB76 WL42 VDD VSS bitcell_6t
XC42_77 BL77 BLB77 WL42 VDD VSS bitcell_6t
XC42_78 BL78 BLB78 WL42 VDD VSS bitcell_6t
XC42_79 BL79 BLB79 WL42 VDD VSS bitcell_6t
XC42_80 BL80 BLB80 WL42 VDD VSS bitcell_6t
XC42_81 BL81 BLB81 WL42 VDD VSS bitcell_6t
XC42_82 BL82 BLB82 WL42 VDD VSS bitcell_6t
XC42_83 BL83 BLB83 WL42 VDD VSS bitcell_6t
XC42_84 BL84 BLB84 WL42 VDD VSS bitcell_6t
XC42_85 BL85 BLB85 WL42 VDD VSS bitcell_6t
XC42_86 BL86 BLB86 WL42 VDD VSS bitcell_6t
XC42_87 BL87 BLB87 WL42 VDD VSS bitcell_6t
XC42_88 BL88 BLB88 WL42 VDD VSS bitcell_6t
XC42_89 BL89 BLB89 WL42 VDD VSS bitcell_6t
XC42_90 BL90 BLB90 WL42 VDD VSS bitcell_6t
XC42_91 BL91 BLB91 WL42 VDD VSS bitcell_6t
XC42_92 BL92 BLB92 WL42 VDD VSS bitcell_6t
XC42_93 BL93 BLB93 WL42 VDD VSS bitcell_6t
XC42_94 BL94 BLB94 WL42 VDD VSS bitcell_6t
XC42_95 BL95 BLB95 WL42 VDD VSS bitcell_6t
XC42_96 BL96 BLB96 WL42 VDD VSS bitcell_6t
XC42_97 BL97 BLB97 WL42 VDD VSS bitcell_6t
XC42_98 BL98 BLB98 WL42 VDD VSS bitcell_6t
XC42_99 BL99 BLB99 WL42 VDD VSS bitcell_6t
XC42_100 BL100 BLB100 WL42 VDD VSS bitcell_6t
XC42_101 BL101 BLB101 WL42 VDD VSS bitcell_6t
XC42_102 BL102 BLB102 WL42 VDD VSS bitcell_6t
XC42_103 BL103 BLB103 WL42 VDD VSS bitcell_6t
XC42_104 BL104 BLB104 WL42 VDD VSS bitcell_6t
XC42_105 BL105 BLB105 WL42 VDD VSS bitcell_6t
XC42_106 BL106 BLB106 WL42 VDD VSS bitcell_6t
XC42_107 BL107 BLB107 WL42 VDD VSS bitcell_6t
XC42_108 BL108 BLB108 WL42 VDD VSS bitcell_6t
XC42_109 BL109 BLB109 WL42 VDD VSS bitcell_6t
XC42_110 BL110 BLB110 WL42 VDD VSS bitcell_6t
XC42_111 BL111 BLB111 WL42 VDD VSS bitcell_6t
XC42_112 BL112 BLB112 WL42 VDD VSS bitcell_6t
XC42_113 BL113 BLB113 WL42 VDD VSS bitcell_6t
XC42_114 BL114 BLB114 WL42 VDD VSS bitcell_6t
XC42_115 BL115 BLB115 WL42 VDD VSS bitcell_6t
XC42_116 BL116 BLB116 WL42 VDD VSS bitcell_6t
XC42_117 BL117 BLB117 WL42 VDD VSS bitcell_6t
XC42_118 BL118 BLB118 WL42 VDD VSS bitcell_6t
XC42_119 BL119 BLB119 WL42 VDD VSS bitcell_6t
XC42_120 BL120 BLB120 WL42 VDD VSS bitcell_6t
XC42_121 BL121 BLB121 WL42 VDD VSS bitcell_6t
XC42_122 BL122 BLB122 WL42 VDD VSS bitcell_6t
XC42_123 BL123 BLB123 WL42 VDD VSS bitcell_6t
XC42_124 BL124 BLB124 WL42 VDD VSS bitcell_6t
XC42_125 BL125 BLB125 WL42 VDD VSS bitcell_6t
XC42_126 BL126 BLB126 WL42 VDD VSS bitcell_6t
XC42_127 BL127 BLB127 WL42 VDD VSS bitcell_6t
XC43_0 BL0 BLB0 WL43 VDD VSS bitcell_6t
XC43_1 BL1 BLB1 WL43 VDD VSS bitcell_6t
XC43_2 BL2 BLB2 WL43 VDD VSS bitcell_6t
XC43_3 BL3 BLB3 WL43 VDD VSS bitcell_6t
XC43_4 BL4 BLB4 WL43 VDD VSS bitcell_6t
XC43_5 BL5 BLB5 WL43 VDD VSS bitcell_6t
XC43_6 BL6 BLB6 WL43 VDD VSS bitcell_6t
XC43_7 BL7 BLB7 WL43 VDD VSS bitcell_6t
XC43_8 BL8 BLB8 WL43 VDD VSS bitcell_6t
XC43_9 BL9 BLB9 WL43 VDD VSS bitcell_6t
XC43_10 BL10 BLB10 WL43 VDD VSS bitcell_6t
XC43_11 BL11 BLB11 WL43 VDD VSS bitcell_6t
XC43_12 BL12 BLB12 WL43 VDD VSS bitcell_6t
XC43_13 BL13 BLB13 WL43 VDD VSS bitcell_6t
XC43_14 BL14 BLB14 WL43 VDD VSS bitcell_6t
XC43_15 BL15 BLB15 WL43 VDD VSS bitcell_6t
XC43_16 BL16 BLB16 WL43 VDD VSS bitcell_6t
XC43_17 BL17 BLB17 WL43 VDD VSS bitcell_6t
XC43_18 BL18 BLB18 WL43 VDD VSS bitcell_6t
XC43_19 BL19 BLB19 WL43 VDD VSS bitcell_6t
XC43_20 BL20 BLB20 WL43 VDD VSS bitcell_6t
XC43_21 BL21 BLB21 WL43 VDD VSS bitcell_6t
XC43_22 BL22 BLB22 WL43 VDD VSS bitcell_6t
XC43_23 BL23 BLB23 WL43 VDD VSS bitcell_6t
XC43_24 BL24 BLB24 WL43 VDD VSS bitcell_6t
XC43_25 BL25 BLB25 WL43 VDD VSS bitcell_6t
XC43_26 BL26 BLB26 WL43 VDD VSS bitcell_6t
XC43_27 BL27 BLB27 WL43 VDD VSS bitcell_6t
XC43_28 BL28 BLB28 WL43 VDD VSS bitcell_6t
XC43_29 BL29 BLB29 WL43 VDD VSS bitcell_6t
XC43_30 BL30 BLB30 WL43 VDD VSS bitcell_6t
XC43_31 BL31 BLB31 WL43 VDD VSS bitcell_6t
XC43_32 BL32 BLB32 WL43 VDD VSS bitcell_6t
XC43_33 BL33 BLB33 WL43 VDD VSS bitcell_6t
XC43_34 BL34 BLB34 WL43 VDD VSS bitcell_6t
XC43_35 BL35 BLB35 WL43 VDD VSS bitcell_6t
XC43_36 BL36 BLB36 WL43 VDD VSS bitcell_6t
XC43_37 BL37 BLB37 WL43 VDD VSS bitcell_6t
XC43_38 BL38 BLB38 WL43 VDD VSS bitcell_6t
XC43_39 BL39 BLB39 WL43 VDD VSS bitcell_6t
XC43_40 BL40 BLB40 WL43 VDD VSS bitcell_6t
XC43_41 BL41 BLB41 WL43 VDD VSS bitcell_6t
XC43_42 BL42 BLB42 WL43 VDD VSS bitcell_6t
XC43_43 BL43 BLB43 WL43 VDD VSS bitcell_6t
XC43_44 BL44 BLB44 WL43 VDD VSS bitcell_6t
XC43_45 BL45 BLB45 WL43 VDD VSS bitcell_6t
XC43_46 BL46 BLB46 WL43 VDD VSS bitcell_6t
XC43_47 BL47 BLB47 WL43 VDD VSS bitcell_6t
XC43_48 BL48 BLB48 WL43 VDD VSS bitcell_6t
XC43_49 BL49 BLB49 WL43 VDD VSS bitcell_6t
XC43_50 BL50 BLB50 WL43 VDD VSS bitcell_6t
XC43_51 BL51 BLB51 WL43 VDD VSS bitcell_6t
XC43_52 BL52 BLB52 WL43 VDD VSS bitcell_6t
XC43_53 BL53 BLB53 WL43 VDD VSS bitcell_6t
XC43_54 BL54 BLB54 WL43 VDD VSS bitcell_6t
XC43_55 BL55 BLB55 WL43 VDD VSS bitcell_6t
XC43_56 BL56 BLB56 WL43 VDD VSS bitcell_6t
XC43_57 BL57 BLB57 WL43 VDD VSS bitcell_6t
XC43_58 BL58 BLB58 WL43 VDD VSS bitcell_6t
XC43_59 BL59 BLB59 WL43 VDD VSS bitcell_6t
XC43_60 BL60 BLB60 WL43 VDD VSS bitcell_6t
XC43_61 BL61 BLB61 WL43 VDD VSS bitcell_6t
XC43_62 BL62 BLB62 WL43 VDD VSS bitcell_6t
XC43_63 BL63 BLB63 WL43 VDD VSS bitcell_6t
XC43_64 BL64 BLB64 WL43 VDD VSS bitcell_6t
XC43_65 BL65 BLB65 WL43 VDD VSS bitcell_6t
XC43_66 BL66 BLB66 WL43 VDD VSS bitcell_6t
XC43_67 BL67 BLB67 WL43 VDD VSS bitcell_6t
XC43_68 BL68 BLB68 WL43 VDD VSS bitcell_6t
XC43_69 BL69 BLB69 WL43 VDD VSS bitcell_6t
XC43_70 BL70 BLB70 WL43 VDD VSS bitcell_6t
XC43_71 BL71 BLB71 WL43 VDD VSS bitcell_6t
XC43_72 BL72 BLB72 WL43 VDD VSS bitcell_6t
XC43_73 BL73 BLB73 WL43 VDD VSS bitcell_6t
XC43_74 BL74 BLB74 WL43 VDD VSS bitcell_6t
XC43_75 BL75 BLB75 WL43 VDD VSS bitcell_6t
XC43_76 BL76 BLB76 WL43 VDD VSS bitcell_6t
XC43_77 BL77 BLB77 WL43 VDD VSS bitcell_6t
XC43_78 BL78 BLB78 WL43 VDD VSS bitcell_6t
XC43_79 BL79 BLB79 WL43 VDD VSS bitcell_6t
XC43_80 BL80 BLB80 WL43 VDD VSS bitcell_6t
XC43_81 BL81 BLB81 WL43 VDD VSS bitcell_6t
XC43_82 BL82 BLB82 WL43 VDD VSS bitcell_6t
XC43_83 BL83 BLB83 WL43 VDD VSS bitcell_6t
XC43_84 BL84 BLB84 WL43 VDD VSS bitcell_6t
XC43_85 BL85 BLB85 WL43 VDD VSS bitcell_6t
XC43_86 BL86 BLB86 WL43 VDD VSS bitcell_6t
XC43_87 BL87 BLB87 WL43 VDD VSS bitcell_6t
XC43_88 BL88 BLB88 WL43 VDD VSS bitcell_6t
XC43_89 BL89 BLB89 WL43 VDD VSS bitcell_6t
XC43_90 BL90 BLB90 WL43 VDD VSS bitcell_6t
XC43_91 BL91 BLB91 WL43 VDD VSS bitcell_6t
XC43_92 BL92 BLB92 WL43 VDD VSS bitcell_6t
XC43_93 BL93 BLB93 WL43 VDD VSS bitcell_6t
XC43_94 BL94 BLB94 WL43 VDD VSS bitcell_6t
XC43_95 BL95 BLB95 WL43 VDD VSS bitcell_6t
XC43_96 BL96 BLB96 WL43 VDD VSS bitcell_6t
XC43_97 BL97 BLB97 WL43 VDD VSS bitcell_6t
XC43_98 BL98 BLB98 WL43 VDD VSS bitcell_6t
XC43_99 BL99 BLB99 WL43 VDD VSS bitcell_6t
XC43_100 BL100 BLB100 WL43 VDD VSS bitcell_6t
XC43_101 BL101 BLB101 WL43 VDD VSS bitcell_6t
XC43_102 BL102 BLB102 WL43 VDD VSS bitcell_6t
XC43_103 BL103 BLB103 WL43 VDD VSS bitcell_6t
XC43_104 BL104 BLB104 WL43 VDD VSS bitcell_6t
XC43_105 BL105 BLB105 WL43 VDD VSS bitcell_6t
XC43_106 BL106 BLB106 WL43 VDD VSS bitcell_6t
XC43_107 BL107 BLB107 WL43 VDD VSS bitcell_6t
XC43_108 BL108 BLB108 WL43 VDD VSS bitcell_6t
XC43_109 BL109 BLB109 WL43 VDD VSS bitcell_6t
XC43_110 BL110 BLB110 WL43 VDD VSS bitcell_6t
XC43_111 BL111 BLB111 WL43 VDD VSS bitcell_6t
XC43_112 BL112 BLB112 WL43 VDD VSS bitcell_6t
XC43_113 BL113 BLB113 WL43 VDD VSS bitcell_6t
XC43_114 BL114 BLB114 WL43 VDD VSS bitcell_6t
XC43_115 BL115 BLB115 WL43 VDD VSS bitcell_6t
XC43_116 BL116 BLB116 WL43 VDD VSS bitcell_6t
XC43_117 BL117 BLB117 WL43 VDD VSS bitcell_6t
XC43_118 BL118 BLB118 WL43 VDD VSS bitcell_6t
XC43_119 BL119 BLB119 WL43 VDD VSS bitcell_6t
XC43_120 BL120 BLB120 WL43 VDD VSS bitcell_6t
XC43_121 BL121 BLB121 WL43 VDD VSS bitcell_6t
XC43_122 BL122 BLB122 WL43 VDD VSS bitcell_6t
XC43_123 BL123 BLB123 WL43 VDD VSS bitcell_6t
XC43_124 BL124 BLB124 WL43 VDD VSS bitcell_6t
XC43_125 BL125 BLB125 WL43 VDD VSS bitcell_6t
XC43_126 BL126 BLB126 WL43 VDD VSS bitcell_6t
XC43_127 BL127 BLB127 WL43 VDD VSS bitcell_6t
XC44_0 BL0 BLB0 WL44 VDD VSS bitcell_6t
XC44_1 BL1 BLB1 WL44 VDD VSS bitcell_6t
XC44_2 BL2 BLB2 WL44 VDD VSS bitcell_6t
XC44_3 BL3 BLB3 WL44 VDD VSS bitcell_6t
XC44_4 BL4 BLB4 WL44 VDD VSS bitcell_6t
XC44_5 BL5 BLB5 WL44 VDD VSS bitcell_6t
XC44_6 BL6 BLB6 WL44 VDD VSS bitcell_6t
XC44_7 BL7 BLB7 WL44 VDD VSS bitcell_6t
XC44_8 BL8 BLB8 WL44 VDD VSS bitcell_6t
XC44_9 BL9 BLB9 WL44 VDD VSS bitcell_6t
XC44_10 BL10 BLB10 WL44 VDD VSS bitcell_6t
XC44_11 BL11 BLB11 WL44 VDD VSS bitcell_6t
XC44_12 BL12 BLB12 WL44 VDD VSS bitcell_6t
XC44_13 BL13 BLB13 WL44 VDD VSS bitcell_6t
XC44_14 BL14 BLB14 WL44 VDD VSS bitcell_6t
XC44_15 BL15 BLB15 WL44 VDD VSS bitcell_6t
XC44_16 BL16 BLB16 WL44 VDD VSS bitcell_6t
XC44_17 BL17 BLB17 WL44 VDD VSS bitcell_6t
XC44_18 BL18 BLB18 WL44 VDD VSS bitcell_6t
XC44_19 BL19 BLB19 WL44 VDD VSS bitcell_6t
XC44_20 BL20 BLB20 WL44 VDD VSS bitcell_6t
XC44_21 BL21 BLB21 WL44 VDD VSS bitcell_6t
XC44_22 BL22 BLB22 WL44 VDD VSS bitcell_6t
XC44_23 BL23 BLB23 WL44 VDD VSS bitcell_6t
XC44_24 BL24 BLB24 WL44 VDD VSS bitcell_6t
XC44_25 BL25 BLB25 WL44 VDD VSS bitcell_6t
XC44_26 BL26 BLB26 WL44 VDD VSS bitcell_6t
XC44_27 BL27 BLB27 WL44 VDD VSS bitcell_6t
XC44_28 BL28 BLB28 WL44 VDD VSS bitcell_6t
XC44_29 BL29 BLB29 WL44 VDD VSS bitcell_6t
XC44_30 BL30 BLB30 WL44 VDD VSS bitcell_6t
XC44_31 BL31 BLB31 WL44 VDD VSS bitcell_6t
XC44_32 BL32 BLB32 WL44 VDD VSS bitcell_6t
XC44_33 BL33 BLB33 WL44 VDD VSS bitcell_6t
XC44_34 BL34 BLB34 WL44 VDD VSS bitcell_6t
XC44_35 BL35 BLB35 WL44 VDD VSS bitcell_6t
XC44_36 BL36 BLB36 WL44 VDD VSS bitcell_6t
XC44_37 BL37 BLB37 WL44 VDD VSS bitcell_6t
XC44_38 BL38 BLB38 WL44 VDD VSS bitcell_6t
XC44_39 BL39 BLB39 WL44 VDD VSS bitcell_6t
XC44_40 BL40 BLB40 WL44 VDD VSS bitcell_6t
XC44_41 BL41 BLB41 WL44 VDD VSS bitcell_6t
XC44_42 BL42 BLB42 WL44 VDD VSS bitcell_6t
XC44_43 BL43 BLB43 WL44 VDD VSS bitcell_6t
XC44_44 BL44 BLB44 WL44 VDD VSS bitcell_6t
XC44_45 BL45 BLB45 WL44 VDD VSS bitcell_6t
XC44_46 BL46 BLB46 WL44 VDD VSS bitcell_6t
XC44_47 BL47 BLB47 WL44 VDD VSS bitcell_6t
XC44_48 BL48 BLB48 WL44 VDD VSS bitcell_6t
XC44_49 BL49 BLB49 WL44 VDD VSS bitcell_6t
XC44_50 BL50 BLB50 WL44 VDD VSS bitcell_6t
XC44_51 BL51 BLB51 WL44 VDD VSS bitcell_6t
XC44_52 BL52 BLB52 WL44 VDD VSS bitcell_6t
XC44_53 BL53 BLB53 WL44 VDD VSS bitcell_6t
XC44_54 BL54 BLB54 WL44 VDD VSS bitcell_6t
XC44_55 BL55 BLB55 WL44 VDD VSS bitcell_6t
XC44_56 BL56 BLB56 WL44 VDD VSS bitcell_6t
XC44_57 BL57 BLB57 WL44 VDD VSS bitcell_6t
XC44_58 BL58 BLB58 WL44 VDD VSS bitcell_6t
XC44_59 BL59 BLB59 WL44 VDD VSS bitcell_6t
XC44_60 BL60 BLB60 WL44 VDD VSS bitcell_6t
XC44_61 BL61 BLB61 WL44 VDD VSS bitcell_6t
XC44_62 BL62 BLB62 WL44 VDD VSS bitcell_6t
XC44_63 BL63 BLB63 WL44 VDD VSS bitcell_6t
XC44_64 BL64 BLB64 WL44 VDD VSS bitcell_6t
XC44_65 BL65 BLB65 WL44 VDD VSS bitcell_6t
XC44_66 BL66 BLB66 WL44 VDD VSS bitcell_6t
XC44_67 BL67 BLB67 WL44 VDD VSS bitcell_6t
XC44_68 BL68 BLB68 WL44 VDD VSS bitcell_6t
XC44_69 BL69 BLB69 WL44 VDD VSS bitcell_6t
XC44_70 BL70 BLB70 WL44 VDD VSS bitcell_6t
XC44_71 BL71 BLB71 WL44 VDD VSS bitcell_6t
XC44_72 BL72 BLB72 WL44 VDD VSS bitcell_6t
XC44_73 BL73 BLB73 WL44 VDD VSS bitcell_6t
XC44_74 BL74 BLB74 WL44 VDD VSS bitcell_6t
XC44_75 BL75 BLB75 WL44 VDD VSS bitcell_6t
XC44_76 BL76 BLB76 WL44 VDD VSS bitcell_6t
XC44_77 BL77 BLB77 WL44 VDD VSS bitcell_6t
XC44_78 BL78 BLB78 WL44 VDD VSS bitcell_6t
XC44_79 BL79 BLB79 WL44 VDD VSS bitcell_6t
XC44_80 BL80 BLB80 WL44 VDD VSS bitcell_6t
XC44_81 BL81 BLB81 WL44 VDD VSS bitcell_6t
XC44_82 BL82 BLB82 WL44 VDD VSS bitcell_6t
XC44_83 BL83 BLB83 WL44 VDD VSS bitcell_6t
XC44_84 BL84 BLB84 WL44 VDD VSS bitcell_6t
XC44_85 BL85 BLB85 WL44 VDD VSS bitcell_6t
XC44_86 BL86 BLB86 WL44 VDD VSS bitcell_6t
XC44_87 BL87 BLB87 WL44 VDD VSS bitcell_6t
XC44_88 BL88 BLB88 WL44 VDD VSS bitcell_6t
XC44_89 BL89 BLB89 WL44 VDD VSS bitcell_6t
XC44_90 BL90 BLB90 WL44 VDD VSS bitcell_6t
XC44_91 BL91 BLB91 WL44 VDD VSS bitcell_6t
XC44_92 BL92 BLB92 WL44 VDD VSS bitcell_6t
XC44_93 BL93 BLB93 WL44 VDD VSS bitcell_6t
XC44_94 BL94 BLB94 WL44 VDD VSS bitcell_6t
XC44_95 BL95 BLB95 WL44 VDD VSS bitcell_6t
XC44_96 BL96 BLB96 WL44 VDD VSS bitcell_6t
XC44_97 BL97 BLB97 WL44 VDD VSS bitcell_6t
XC44_98 BL98 BLB98 WL44 VDD VSS bitcell_6t
XC44_99 BL99 BLB99 WL44 VDD VSS bitcell_6t
XC44_100 BL100 BLB100 WL44 VDD VSS bitcell_6t
XC44_101 BL101 BLB101 WL44 VDD VSS bitcell_6t
XC44_102 BL102 BLB102 WL44 VDD VSS bitcell_6t
XC44_103 BL103 BLB103 WL44 VDD VSS bitcell_6t
XC44_104 BL104 BLB104 WL44 VDD VSS bitcell_6t
XC44_105 BL105 BLB105 WL44 VDD VSS bitcell_6t
XC44_106 BL106 BLB106 WL44 VDD VSS bitcell_6t
XC44_107 BL107 BLB107 WL44 VDD VSS bitcell_6t
XC44_108 BL108 BLB108 WL44 VDD VSS bitcell_6t
XC44_109 BL109 BLB109 WL44 VDD VSS bitcell_6t
XC44_110 BL110 BLB110 WL44 VDD VSS bitcell_6t
XC44_111 BL111 BLB111 WL44 VDD VSS bitcell_6t
XC44_112 BL112 BLB112 WL44 VDD VSS bitcell_6t
XC44_113 BL113 BLB113 WL44 VDD VSS bitcell_6t
XC44_114 BL114 BLB114 WL44 VDD VSS bitcell_6t
XC44_115 BL115 BLB115 WL44 VDD VSS bitcell_6t
XC44_116 BL116 BLB116 WL44 VDD VSS bitcell_6t
XC44_117 BL117 BLB117 WL44 VDD VSS bitcell_6t
XC44_118 BL118 BLB118 WL44 VDD VSS bitcell_6t
XC44_119 BL119 BLB119 WL44 VDD VSS bitcell_6t
XC44_120 BL120 BLB120 WL44 VDD VSS bitcell_6t
XC44_121 BL121 BLB121 WL44 VDD VSS bitcell_6t
XC44_122 BL122 BLB122 WL44 VDD VSS bitcell_6t
XC44_123 BL123 BLB123 WL44 VDD VSS bitcell_6t
XC44_124 BL124 BLB124 WL44 VDD VSS bitcell_6t
XC44_125 BL125 BLB125 WL44 VDD VSS bitcell_6t
XC44_126 BL126 BLB126 WL44 VDD VSS bitcell_6t
XC44_127 BL127 BLB127 WL44 VDD VSS bitcell_6t
XC45_0 BL0 BLB0 WL45 VDD VSS bitcell_6t
XC45_1 BL1 BLB1 WL45 VDD VSS bitcell_6t
XC45_2 BL2 BLB2 WL45 VDD VSS bitcell_6t
XC45_3 BL3 BLB3 WL45 VDD VSS bitcell_6t
XC45_4 BL4 BLB4 WL45 VDD VSS bitcell_6t
XC45_5 BL5 BLB5 WL45 VDD VSS bitcell_6t
XC45_6 BL6 BLB6 WL45 VDD VSS bitcell_6t
XC45_7 BL7 BLB7 WL45 VDD VSS bitcell_6t
XC45_8 BL8 BLB8 WL45 VDD VSS bitcell_6t
XC45_9 BL9 BLB9 WL45 VDD VSS bitcell_6t
XC45_10 BL10 BLB10 WL45 VDD VSS bitcell_6t
XC45_11 BL11 BLB11 WL45 VDD VSS bitcell_6t
XC45_12 BL12 BLB12 WL45 VDD VSS bitcell_6t
XC45_13 BL13 BLB13 WL45 VDD VSS bitcell_6t
XC45_14 BL14 BLB14 WL45 VDD VSS bitcell_6t
XC45_15 BL15 BLB15 WL45 VDD VSS bitcell_6t
XC45_16 BL16 BLB16 WL45 VDD VSS bitcell_6t
XC45_17 BL17 BLB17 WL45 VDD VSS bitcell_6t
XC45_18 BL18 BLB18 WL45 VDD VSS bitcell_6t
XC45_19 BL19 BLB19 WL45 VDD VSS bitcell_6t
XC45_20 BL20 BLB20 WL45 VDD VSS bitcell_6t
XC45_21 BL21 BLB21 WL45 VDD VSS bitcell_6t
XC45_22 BL22 BLB22 WL45 VDD VSS bitcell_6t
XC45_23 BL23 BLB23 WL45 VDD VSS bitcell_6t
XC45_24 BL24 BLB24 WL45 VDD VSS bitcell_6t
XC45_25 BL25 BLB25 WL45 VDD VSS bitcell_6t
XC45_26 BL26 BLB26 WL45 VDD VSS bitcell_6t
XC45_27 BL27 BLB27 WL45 VDD VSS bitcell_6t
XC45_28 BL28 BLB28 WL45 VDD VSS bitcell_6t
XC45_29 BL29 BLB29 WL45 VDD VSS bitcell_6t
XC45_30 BL30 BLB30 WL45 VDD VSS bitcell_6t
XC45_31 BL31 BLB31 WL45 VDD VSS bitcell_6t
XC45_32 BL32 BLB32 WL45 VDD VSS bitcell_6t
XC45_33 BL33 BLB33 WL45 VDD VSS bitcell_6t
XC45_34 BL34 BLB34 WL45 VDD VSS bitcell_6t
XC45_35 BL35 BLB35 WL45 VDD VSS bitcell_6t
XC45_36 BL36 BLB36 WL45 VDD VSS bitcell_6t
XC45_37 BL37 BLB37 WL45 VDD VSS bitcell_6t
XC45_38 BL38 BLB38 WL45 VDD VSS bitcell_6t
XC45_39 BL39 BLB39 WL45 VDD VSS bitcell_6t
XC45_40 BL40 BLB40 WL45 VDD VSS bitcell_6t
XC45_41 BL41 BLB41 WL45 VDD VSS bitcell_6t
XC45_42 BL42 BLB42 WL45 VDD VSS bitcell_6t
XC45_43 BL43 BLB43 WL45 VDD VSS bitcell_6t
XC45_44 BL44 BLB44 WL45 VDD VSS bitcell_6t
XC45_45 BL45 BLB45 WL45 VDD VSS bitcell_6t
XC45_46 BL46 BLB46 WL45 VDD VSS bitcell_6t
XC45_47 BL47 BLB47 WL45 VDD VSS bitcell_6t
XC45_48 BL48 BLB48 WL45 VDD VSS bitcell_6t
XC45_49 BL49 BLB49 WL45 VDD VSS bitcell_6t
XC45_50 BL50 BLB50 WL45 VDD VSS bitcell_6t
XC45_51 BL51 BLB51 WL45 VDD VSS bitcell_6t
XC45_52 BL52 BLB52 WL45 VDD VSS bitcell_6t
XC45_53 BL53 BLB53 WL45 VDD VSS bitcell_6t
XC45_54 BL54 BLB54 WL45 VDD VSS bitcell_6t
XC45_55 BL55 BLB55 WL45 VDD VSS bitcell_6t
XC45_56 BL56 BLB56 WL45 VDD VSS bitcell_6t
XC45_57 BL57 BLB57 WL45 VDD VSS bitcell_6t
XC45_58 BL58 BLB58 WL45 VDD VSS bitcell_6t
XC45_59 BL59 BLB59 WL45 VDD VSS bitcell_6t
XC45_60 BL60 BLB60 WL45 VDD VSS bitcell_6t
XC45_61 BL61 BLB61 WL45 VDD VSS bitcell_6t
XC45_62 BL62 BLB62 WL45 VDD VSS bitcell_6t
XC45_63 BL63 BLB63 WL45 VDD VSS bitcell_6t
XC45_64 BL64 BLB64 WL45 VDD VSS bitcell_6t
XC45_65 BL65 BLB65 WL45 VDD VSS bitcell_6t
XC45_66 BL66 BLB66 WL45 VDD VSS bitcell_6t
XC45_67 BL67 BLB67 WL45 VDD VSS bitcell_6t
XC45_68 BL68 BLB68 WL45 VDD VSS bitcell_6t
XC45_69 BL69 BLB69 WL45 VDD VSS bitcell_6t
XC45_70 BL70 BLB70 WL45 VDD VSS bitcell_6t
XC45_71 BL71 BLB71 WL45 VDD VSS bitcell_6t
XC45_72 BL72 BLB72 WL45 VDD VSS bitcell_6t
XC45_73 BL73 BLB73 WL45 VDD VSS bitcell_6t
XC45_74 BL74 BLB74 WL45 VDD VSS bitcell_6t
XC45_75 BL75 BLB75 WL45 VDD VSS bitcell_6t
XC45_76 BL76 BLB76 WL45 VDD VSS bitcell_6t
XC45_77 BL77 BLB77 WL45 VDD VSS bitcell_6t
XC45_78 BL78 BLB78 WL45 VDD VSS bitcell_6t
XC45_79 BL79 BLB79 WL45 VDD VSS bitcell_6t
XC45_80 BL80 BLB80 WL45 VDD VSS bitcell_6t
XC45_81 BL81 BLB81 WL45 VDD VSS bitcell_6t
XC45_82 BL82 BLB82 WL45 VDD VSS bitcell_6t
XC45_83 BL83 BLB83 WL45 VDD VSS bitcell_6t
XC45_84 BL84 BLB84 WL45 VDD VSS bitcell_6t
XC45_85 BL85 BLB85 WL45 VDD VSS bitcell_6t
XC45_86 BL86 BLB86 WL45 VDD VSS bitcell_6t
XC45_87 BL87 BLB87 WL45 VDD VSS bitcell_6t
XC45_88 BL88 BLB88 WL45 VDD VSS bitcell_6t
XC45_89 BL89 BLB89 WL45 VDD VSS bitcell_6t
XC45_90 BL90 BLB90 WL45 VDD VSS bitcell_6t
XC45_91 BL91 BLB91 WL45 VDD VSS bitcell_6t
XC45_92 BL92 BLB92 WL45 VDD VSS bitcell_6t
XC45_93 BL93 BLB93 WL45 VDD VSS bitcell_6t
XC45_94 BL94 BLB94 WL45 VDD VSS bitcell_6t
XC45_95 BL95 BLB95 WL45 VDD VSS bitcell_6t
XC45_96 BL96 BLB96 WL45 VDD VSS bitcell_6t
XC45_97 BL97 BLB97 WL45 VDD VSS bitcell_6t
XC45_98 BL98 BLB98 WL45 VDD VSS bitcell_6t
XC45_99 BL99 BLB99 WL45 VDD VSS bitcell_6t
XC45_100 BL100 BLB100 WL45 VDD VSS bitcell_6t
XC45_101 BL101 BLB101 WL45 VDD VSS bitcell_6t
XC45_102 BL102 BLB102 WL45 VDD VSS bitcell_6t
XC45_103 BL103 BLB103 WL45 VDD VSS bitcell_6t
XC45_104 BL104 BLB104 WL45 VDD VSS bitcell_6t
XC45_105 BL105 BLB105 WL45 VDD VSS bitcell_6t
XC45_106 BL106 BLB106 WL45 VDD VSS bitcell_6t
XC45_107 BL107 BLB107 WL45 VDD VSS bitcell_6t
XC45_108 BL108 BLB108 WL45 VDD VSS bitcell_6t
XC45_109 BL109 BLB109 WL45 VDD VSS bitcell_6t
XC45_110 BL110 BLB110 WL45 VDD VSS bitcell_6t
XC45_111 BL111 BLB111 WL45 VDD VSS bitcell_6t
XC45_112 BL112 BLB112 WL45 VDD VSS bitcell_6t
XC45_113 BL113 BLB113 WL45 VDD VSS bitcell_6t
XC45_114 BL114 BLB114 WL45 VDD VSS bitcell_6t
XC45_115 BL115 BLB115 WL45 VDD VSS bitcell_6t
XC45_116 BL116 BLB116 WL45 VDD VSS bitcell_6t
XC45_117 BL117 BLB117 WL45 VDD VSS bitcell_6t
XC45_118 BL118 BLB118 WL45 VDD VSS bitcell_6t
XC45_119 BL119 BLB119 WL45 VDD VSS bitcell_6t
XC45_120 BL120 BLB120 WL45 VDD VSS bitcell_6t
XC45_121 BL121 BLB121 WL45 VDD VSS bitcell_6t
XC45_122 BL122 BLB122 WL45 VDD VSS bitcell_6t
XC45_123 BL123 BLB123 WL45 VDD VSS bitcell_6t
XC45_124 BL124 BLB124 WL45 VDD VSS bitcell_6t
XC45_125 BL125 BLB125 WL45 VDD VSS bitcell_6t
XC45_126 BL126 BLB126 WL45 VDD VSS bitcell_6t
XC45_127 BL127 BLB127 WL45 VDD VSS bitcell_6t
XC46_0 BL0 BLB0 WL46 VDD VSS bitcell_6t
XC46_1 BL1 BLB1 WL46 VDD VSS bitcell_6t
XC46_2 BL2 BLB2 WL46 VDD VSS bitcell_6t
XC46_3 BL3 BLB3 WL46 VDD VSS bitcell_6t
XC46_4 BL4 BLB4 WL46 VDD VSS bitcell_6t
XC46_5 BL5 BLB5 WL46 VDD VSS bitcell_6t
XC46_6 BL6 BLB6 WL46 VDD VSS bitcell_6t
XC46_7 BL7 BLB7 WL46 VDD VSS bitcell_6t
XC46_8 BL8 BLB8 WL46 VDD VSS bitcell_6t
XC46_9 BL9 BLB9 WL46 VDD VSS bitcell_6t
XC46_10 BL10 BLB10 WL46 VDD VSS bitcell_6t
XC46_11 BL11 BLB11 WL46 VDD VSS bitcell_6t
XC46_12 BL12 BLB12 WL46 VDD VSS bitcell_6t
XC46_13 BL13 BLB13 WL46 VDD VSS bitcell_6t
XC46_14 BL14 BLB14 WL46 VDD VSS bitcell_6t
XC46_15 BL15 BLB15 WL46 VDD VSS bitcell_6t
XC46_16 BL16 BLB16 WL46 VDD VSS bitcell_6t
XC46_17 BL17 BLB17 WL46 VDD VSS bitcell_6t
XC46_18 BL18 BLB18 WL46 VDD VSS bitcell_6t
XC46_19 BL19 BLB19 WL46 VDD VSS bitcell_6t
XC46_20 BL20 BLB20 WL46 VDD VSS bitcell_6t
XC46_21 BL21 BLB21 WL46 VDD VSS bitcell_6t
XC46_22 BL22 BLB22 WL46 VDD VSS bitcell_6t
XC46_23 BL23 BLB23 WL46 VDD VSS bitcell_6t
XC46_24 BL24 BLB24 WL46 VDD VSS bitcell_6t
XC46_25 BL25 BLB25 WL46 VDD VSS bitcell_6t
XC46_26 BL26 BLB26 WL46 VDD VSS bitcell_6t
XC46_27 BL27 BLB27 WL46 VDD VSS bitcell_6t
XC46_28 BL28 BLB28 WL46 VDD VSS bitcell_6t
XC46_29 BL29 BLB29 WL46 VDD VSS bitcell_6t
XC46_30 BL30 BLB30 WL46 VDD VSS bitcell_6t
XC46_31 BL31 BLB31 WL46 VDD VSS bitcell_6t
XC46_32 BL32 BLB32 WL46 VDD VSS bitcell_6t
XC46_33 BL33 BLB33 WL46 VDD VSS bitcell_6t
XC46_34 BL34 BLB34 WL46 VDD VSS bitcell_6t
XC46_35 BL35 BLB35 WL46 VDD VSS bitcell_6t
XC46_36 BL36 BLB36 WL46 VDD VSS bitcell_6t
XC46_37 BL37 BLB37 WL46 VDD VSS bitcell_6t
XC46_38 BL38 BLB38 WL46 VDD VSS bitcell_6t
XC46_39 BL39 BLB39 WL46 VDD VSS bitcell_6t
XC46_40 BL40 BLB40 WL46 VDD VSS bitcell_6t
XC46_41 BL41 BLB41 WL46 VDD VSS bitcell_6t
XC46_42 BL42 BLB42 WL46 VDD VSS bitcell_6t
XC46_43 BL43 BLB43 WL46 VDD VSS bitcell_6t
XC46_44 BL44 BLB44 WL46 VDD VSS bitcell_6t
XC46_45 BL45 BLB45 WL46 VDD VSS bitcell_6t
XC46_46 BL46 BLB46 WL46 VDD VSS bitcell_6t
XC46_47 BL47 BLB47 WL46 VDD VSS bitcell_6t
XC46_48 BL48 BLB48 WL46 VDD VSS bitcell_6t
XC46_49 BL49 BLB49 WL46 VDD VSS bitcell_6t
XC46_50 BL50 BLB50 WL46 VDD VSS bitcell_6t
XC46_51 BL51 BLB51 WL46 VDD VSS bitcell_6t
XC46_52 BL52 BLB52 WL46 VDD VSS bitcell_6t
XC46_53 BL53 BLB53 WL46 VDD VSS bitcell_6t
XC46_54 BL54 BLB54 WL46 VDD VSS bitcell_6t
XC46_55 BL55 BLB55 WL46 VDD VSS bitcell_6t
XC46_56 BL56 BLB56 WL46 VDD VSS bitcell_6t
XC46_57 BL57 BLB57 WL46 VDD VSS bitcell_6t
XC46_58 BL58 BLB58 WL46 VDD VSS bitcell_6t
XC46_59 BL59 BLB59 WL46 VDD VSS bitcell_6t
XC46_60 BL60 BLB60 WL46 VDD VSS bitcell_6t
XC46_61 BL61 BLB61 WL46 VDD VSS bitcell_6t
XC46_62 BL62 BLB62 WL46 VDD VSS bitcell_6t
XC46_63 BL63 BLB63 WL46 VDD VSS bitcell_6t
XC46_64 BL64 BLB64 WL46 VDD VSS bitcell_6t
XC46_65 BL65 BLB65 WL46 VDD VSS bitcell_6t
XC46_66 BL66 BLB66 WL46 VDD VSS bitcell_6t
XC46_67 BL67 BLB67 WL46 VDD VSS bitcell_6t
XC46_68 BL68 BLB68 WL46 VDD VSS bitcell_6t
XC46_69 BL69 BLB69 WL46 VDD VSS bitcell_6t
XC46_70 BL70 BLB70 WL46 VDD VSS bitcell_6t
XC46_71 BL71 BLB71 WL46 VDD VSS bitcell_6t
XC46_72 BL72 BLB72 WL46 VDD VSS bitcell_6t
XC46_73 BL73 BLB73 WL46 VDD VSS bitcell_6t
XC46_74 BL74 BLB74 WL46 VDD VSS bitcell_6t
XC46_75 BL75 BLB75 WL46 VDD VSS bitcell_6t
XC46_76 BL76 BLB76 WL46 VDD VSS bitcell_6t
XC46_77 BL77 BLB77 WL46 VDD VSS bitcell_6t
XC46_78 BL78 BLB78 WL46 VDD VSS bitcell_6t
XC46_79 BL79 BLB79 WL46 VDD VSS bitcell_6t
XC46_80 BL80 BLB80 WL46 VDD VSS bitcell_6t
XC46_81 BL81 BLB81 WL46 VDD VSS bitcell_6t
XC46_82 BL82 BLB82 WL46 VDD VSS bitcell_6t
XC46_83 BL83 BLB83 WL46 VDD VSS bitcell_6t
XC46_84 BL84 BLB84 WL46 VDD VSS bitcell_6t
XC46_85 BL85 BLB85 WL46 VDD VSS bitcell_6t
XC46_86 BL86 BLB86 WL46 VDD VSS bitcell_6t
XC46_87 BL87 BLB87 WL46 VDD VSS bitcell_6t
XC46_88 BL88 BLB88 WL46 VDD VSS bitcell_6t
XC46_89 BL89 BLB89 WL46 VDD VSS bitcell_6t
XC46_90 BL90 BLB90 WL46 VDD VSS bitcell_6t
XC46_91 BL91 BLB91 WL46 VDD VSS bitcell_6t
XC46_92 BL92 BLB92 WL46 VDD VSS bitcell_6t
XC46_93 BL93 BLB93 WL46 VDD VSS bitcell_6t
XC46_94 BL94 BLB94 WL46 VDD VSS bitcell_6t
XC46_95 BL95 BLB95 WL46 VDD VSS bitcell_6t
XC46_96 BL96 BLB96 WL46 VDD VSS bitcell_6t
XC46_97 BL97 BLB97 WL46 VDD VSS bitcell_6t
XC46_98 BL98 BLB98 WL46 VDD VSS bitcell_6t
XC46_99 BL99 BLB99 WL46 VDD VSS bitcell_6t
XC46_100 BL100 BLB100 WL46 VDD VSS bitcell_6t
XC46_101 BL101 BLB101 WL46 VDD VSS bitcell_6t
XC46_102 BL102 BLB102 WL46 VDD VSS bitcell_6t
XC46_103 BL103 BLB103 WL46 VDD VSS bitcell_6t
XC46_104 BL104 BLB104 WL46 VDD VSS bitcell_6t
XC46_105 BL105 BLB105 WL46 VDD VSS bitcell_6t
XC46_106 BL106 BLB106 WL46 VDD VSS bitcell_6t
XC46_107 BL107 BLB107 WL46 VDD VSS bitcell_6t
XC46_108 BL108 BLB108 WL46 VDD VSS bitcell_6t
XC46_109 BL109 BLB109 WL46 VDD VSS bitcell_6t
XC46_110 BL110 BLB110 WL46 VDD VSS bitcell_6t
XC46_111 BL111 BLB111 WL46 VDD VSS bitcell_6t
XC46_112 BL112 BLB112 WL46 VDD VSS bitcell_6t
XC46_113 BL113 BLB113 WL46 VDD VSS bitcell_6t
XC46_114 BL114 BLB114 WL46 VDD VSS bitcell_6t
XC46_115 BL115 BLB115 WL46 VDD VSS bitcell_6t
XC46_116 BL116 BLB116 WL46 VDD VSS bitcell_6t
XC46_117 BL117 BLB117 WL46 VDD VSS bitcell_6t
XC46_118 BL118 BLB118 WL46 VDD VSS bitcell_6t
XC46_119 BL119 BLB119 WL46 VDD VSS bitcell_6t
XC46_120 BL120 BLB120 WL46 VDD VSS bitcell_6t
XC46_121 BL121 BLB121 WL46 VDD VSS bitcell_6t
XC46_122 BL122 BLB122 WL46 VDD VSS bitcell_6t
XC46_123 BL123 BLB123 WL46 VDD VSS bitcell_6t
XC46_124 BL124 BLB124 WL46 VDD VSS bitcell_6t
XC46_125 BL125 BLB125 WL46 VDD VSS bitcell_6t
XC46_126 BL126 BLB126 WL46 VDD VSS bitcell_6t
XC46_127 BL127 BLB127 WL46 VDD VSS bitcell_6t
XC47_0 BL0 BLB0 WL47 VDD VSS bitcell_6t
XC47_1 BL1 BLB1 WL47 VDD VSS bitcell_6t
XC47_2 BL2 BLB2 WL47 VDD VSS bitcell_6t
XC47_3 BL3 BLB3 WL47 VDD VSS bitcell_6t
XC47_4 BL4 BLB4 WL47 VDD VSS bitcell_6t
XC47_5 BL5 BLB5 WL47 VDD VSS bitcell_6t
XC47_6 BL6 BLB6 WL47 VDD VSS bitcell_6t
XC47_7 BL7 BLB7 WL47 VDD VSS bitcell_6t
XC47_8 BL8 BLB8 WL47 VDD VSS bitcell_6t
XC47_9 BL9 BLB9 WL47 VDD VSS bitcell_6t
XC47_10 BL10 BLB10 WL47 VDD VSS bitcell_6t
XC47_11 BL11 BLB11 WL47 VDD VSS bitcell_6t
XC47_12 BL12 BLB12 WL47 VDD VSS bitcell_6t
XC47_13 BL13 BLB13 WL47 VDD VSS bitcell_6t
XC47_14 BL14 BLB14 WL47 VDD VSS bitcell_6t
XC47_15 BL15 BLB15 WL47 VDD VSS bitcell_6t
XC47_16 BL16 BLB16 WL47 VDD VSS bitcell_6t
XC47_17 BL17 BLB17 WL47 VDD VSS bitcell_6t
XC47_18 BL18 BLB18 WL47 VDD VSS bitcell_6t
XC47_19 BL19 BLB19 WL47 VDD VSS bitcell_6t
XC47_20 BL20 BLB20 WL47 VDD VSS bitcell_6t
XC47_21 BL21 BLB21 WL47 VDD VSS bitcell_6t
XC47_22 BL22 BLB22 WL47 VDD VSS bitcell_6t
XC47_23 BL23 BLB23 WL47 VDD VSS bitcell_6t
XC47_24 BL24 BLB24 WL47 VDD VSS bitcell_6t
XC47_25 BL25 BLB25 WL47 VDD VSS bitcell_6t
XC47_26 BL26 BLB26 WL47 VDD VSS bitcell_6t
XC47_27 BL27 BLB27 WL47 VDD VSS bitcell_6t
XC47_28 BL28 BLB28 WL47 VDD VSS bitcell_6t
XC47_29 BL29 BLB29 WL47 VDD VSS bitcell_6t
XC47_30 BL30 BLB30 WL47 VDD VSS bitcell_6t
XC47_31 BL31 BLB31 WL47 VDD VSS bitcell_6t
XC47_32 BL32 BLB32 WL47 VDD VSS bitcell_6t
XC47_33 BL33 BLB33 WL47 VDD VSS bitcell_6t
XC47_34 BL34 BLB34 WL47 VDD VSS bitcell_6t
XC47_35 BL35 BLB35 WL47 VDD VSS bitcell_6t
XC47_36 BL36 BLB36 WL47 VDD VSS bitcell_6t
XC47_37 BL37 BLB37 WL47 VDD VSS bitcell_6t
XC47_38 BL38 BLB38 WL47 VDD VSS bitcell_6t
XC47_39 BL39 BLB39 WL47 VDD VSS bitcell_6t
XC47_40 BL40 BLB40 WL47 VDD VSS bitcell_6t
XC47_41 BL41 BLB41 WL47 VDD VSS bitcell_6t
XC47_42 BL42 BLB42 WL47 VDD VSS bitcell_6t
XC47_43 BL43 BLB43 WL47 VDD VSS bitcell_6t
XC47_44 BL44 BLB44 WL47 VDD VSS bitcell_6t
XC47_45 BL45 BLB45 WL47 VDD VSS bitcell_6t
XC47_46 BL46 BLB46 WL47 VDD VSS bitcell_6t
XC47_47 BL47 BLB47 WL47 VDD VSS bitcell_6t
XC47_48 BL48 BLB48 WL47 VDD VSS bitcell_6t
XC47_49 BL49 BLB49 WL47 VDD VSS bitcell_6t
XC47_50 BL50 BLB50 WL47 VDD VSS bitcell_6t
XC47_51 BL51 BLB51 WL47 VDD VSS bitcell_6t
XC47_52 BL52 BLB52 WL47 VDD VSS bitcell_6t
XC47_53 BL53 BLB53 WL47 VDD VSS bitcell_6t
XC47_54 BL54 BLB54 WL47 VDD VSS bitcell_6t
XC47_55 BL55 BLB55 WL47 VDD VSS bitcell_6t
XC47_56 BL56 BLB56 WL47 VDD VSS bitcell_6t
XC47_57 BL57 BLB57 WL47 VDD VSS bitcell_6t
XC47_58 BL58 BLB58 WL47 VDD VSS bitcell_6t
XC47_59 BL59 BLB59 WL47 VDD VSS bitcell_6t
XC47_60 BL60 BLB60 WL47 VDD VSS bitcell_6t
XC47_61 BL61 BLB61 WL47 VDD VSS bitcell_6t
XC47_62 BL62 BLB62 WL47 VDD VSS bitcell_6t
XC47_63 BL63 BLB63 WL47 VDD VSS bitcell_6t
XC47_64 BL64 BLB64 WL47 VDD VSS bitcell_6t
XC47_65 BL65 BLB65 WL47 VDD VSS bitcell_6t
XC47_66 BL66 BLB66 WL47 VDD VSS bitcell_6t
XC47_67 BL67 BLB67 WL47 VDD VSS bitcell_6t
XC47_68 BL68 BLB68 WL47 VDD VSS bitcell_6t
XC47_69 BL69 BLB69 WL47 VDD VSS bitcell_6t
XC47_70 BL70 BLB70 WL47 VDD VSS bitcell_6t
XC47_71 BL71 BLB71 WL47 VDD VSS bitcell_6t
XC47_72 BL72 BLB72 WL47 VDD VSS bitcell_6t
XC47_73 BL73 BLB73 WL47 VDD VSS bitcell_6t
XC47_74 BL74 BLB74 WL47 VDD VSS bitcell_6t
XC47_75 BL75 BLB75 WL47 VDD VSS bitcell_6t
XC47_76 BL76 BLB76 WL47 VDD VSS bitcell_6t
XC47_77 BL77 BLB77 WL47 VDD VSS bitcell_6t
XC47_78 BL78 BLB78 WL47 VDD VSS bitcell_6t
XC47_79 BL79 BLB79 WL47 VDD VSS bitcell_6t
XC47_80 BL80 BLB80 WL47 VDD VSS bitcell_6t
XC47_81 BL81 BLB81 WL47 VDD VSS bitcell_6t
XC47_82 BL82 BLB82 WL47 VDD VSS bitcell_6t
XC47_83 BL83 BLB83 WL47 VDD VSS bitcell_6t
XC47_84 BL84 BLB84 WL47 VDD VSS bitcell_6t
XC47_85 BL85 BLB85 WL47 VDD VSS bitcell_6t
XC47_86 BL86 BLB86 WL47 VDD VSS bitcell_6t
XC47_87 BL87 BLB87 WL47 VDD VSS bitcell_6t
XC47_88 BL88 BLB88 WL47 VDD VSS bitcell_6t
XC47_89 BL89 BLB89 WL47 VDD VSS bitcell_6t
XC47_90 BL90 BLB90 WL47 VDD VSS bitcell_6t
XC47_91 BL91 BLB91 WL47 VDD VSS bitcell_6t
XC47_92 BL92 BLB92 WL47 VDD VSS bitcell_6t
XC47_93 BL93 BLB93 WL47 VDD VSS bitcell_6t
XC47_94 BL94 BLB94 WL47 VDD VSS bitcell_6t
XC47_95 BL95 BLB95 WL47 VDD VSS bitcell_6t
XC47_96 BL96 BLB96 WL47 VDD VSS bitcell_6t
XC47_97 BL97 BLB97 WL47 VDD VSS bitcell_6t
XC47_98 BL98 BLB98 WL47 VDD VSS bitcell_6t
XC47_99 BL99 BLB99 WL47 VDD VSS bitcell_6t
XC47_100 BL100 BLB100 WL47 VDD VSS bitcell_6t
XC47_101 BL101 BLB101 WL47 VDD VSS bitcell_6t
XC47_102 BL102 BLB102 WL47 VDD VSS bitcell_6t
XC47_103 BL103 BLB103 WL47 VDD VSS bitcell_6t
XC47_104 BL104 BLB104 WL47 VDD VSS bitcell_6t
XC47_105 BL105 BLB105 WL47 VDD VSS bitcell_6t
XC47_106 BL106 BLB106 WL47 VDD VSS bitcell_6t
XC47_107 BL107 BLB107 WL47 VDD VSS bitcell_6t
XC47_108 BL108 BLB108 WL47 VDD VSS bitcell_6t
XC47_109 BL109 BLB109 WL47 VDD VSS bitcell_6t
XC47_110 BL110 BLB110 WL47 VDD VSS bitcell_6t
XC47_111 BL111 BLB111 WL47 VDD VSS bitcell_6t
XC47_112 BL112 BLB112 WL47 VDD VSS bitcell_6t
XC47_113 BL113 BLB113 WL47 VDD VSS bitcell_6t
XC47_114 BL114 BLB114 WL47 VDD VSS bitcell_6t
XC47_115 BL115 BLB115 WL47 VDD VSS bitcell_6t
XC47_116 BL116 BLB116 WL47 VDD VSS bitcell_6t
XC47_117 BL117 BLB117 WL47 VDD VSS bitcell_6t
XC47_118 BL118 BLB118 WL47 VDD VSS bitcell_6t
XC47_119 BL119 BLB119 WL47 VDD VSS bitcell_6t
XC47_120 BL120 BLB120 WL47 VDD VSS bitcell_6t
XC47_121 BL121 BLB121 WL47 VDD VSS bitcell_6t
XC47_122 BL122 BLB122 WL47 VDD VSS bitcell_6t
XC47_123 BL123 BLB123 WL47 VDD VSS bitcell_6t
XC47_124 BL124 BLB124 WL47 VDD VSS bitcell_6t
XC47_125 BL125 BLB125 WL47 VDD VSS bitcell_6t
XC47_126 BL126 BLB126 WL47 VDD VSS bitcell_6t
XC47_127 BL127 BLB127 WL47 VDD VSS bitcell_6t
XC48_0 BL0 BLB0 WL48 VDD VSS bitcell_6t
XC48_1 BL1 BLB1 WL48 VDD VSS bitcell_6t
XC48_2 BL2 BLB2 WL48 VDD VSS bitcell_6t
XC48_3 BL3 BLB3 WL48 VDD VSS bitcell_6t
XC48_4 BL4 BLB4 WL48 VDD VSS bitcell_6t
XC48_5 BL5 BLB5 WL48 VDD VSS bitcell_6t
XC48_6 BL6 BLB6 WL48 VDD VSS bitcell_6t
XC48_7 BL7 BLB7 WL48 VDD VSS bitcell_6t
XC48_8 BL8 BLB8 WL48 VDD VSS bitcell_6t
XC48_9 BL9 BLB9 WL48 VDD VSS bitcell_6t
XC48_10 BL10 BLB10 WL48 VDD VSS bitcell_6t
XC48_11 BL11 BLB11 WL48 VDD VSS bitcell_6t
XC48_12 BL12 BLB12 WL48 VDD VSS bitcell_6t
XC48_13 BL13 BLB13 WL48 VDD VSS bitcell_6t
XC48_14 BL14 BLB14 WL48 VDD VSS bitcell_6t
XC48_15 BL15 BLB15 WL48 VDD VSS bitcell_6t
XC48_16 BL16 BLB16 WL48 VDD VSS bitcell_6t
XC48_17 BL17 BLB17 WL48 VDD VSS bitcell_6t
XC48_18 BL18 BLB18 WL48 VDD VSS bitcell_6t
XC48_19 BL19 BLB19 WL48 VDD VSS bitcell_6t
XC48_20 BL20 BLB20 WL48 VDD VSS bitcell_6t
XC48_21 BL21 BLB21 WL48 VDD VSS bitcell_6t
XC48_22 BL22 BLB22 WL48 VDD VSS bitcell_6t
XC48_23 BL23 BLB23 WL48 VDD VSS bitcell_6t
XC48_24 BL24 BLB24 WL48 VDD VSS bitcell_6t
XC48_25 BL25 BLB25 WL48 VDD VSS bitcell_6t
XC48_26 BL26 BLB26 WL48 VDD VSS bitcell_6t
XC48_27 BL27 BLB27 WL48 VDD VSS bitcell_6t
XC48_28 BL28 BLB28 WL48 VDD VSS bitcell_6t
XC48_29 BL29 BLB29 WL48 VDD VSS bitcell_6t
XC48_30 BL30 BLB30 WL48 VDD VSS bitcell_6t
XC48_31 BL31 BLB31 WL48 VDD VSS bitcell_6t
XC48_32 BL32 BLB32 WL48 VDD VSS bitcell_6t
XC48_33 BL33 BLB33 WL48 VDD VSS bitcell_6t
XC48_34 BL34 BLB34 WL48 VDD VSS bitcell_6t
XC48_35 BL35 BLB35 WL48 VDD VSS bitcell_6t
XC48_36 BL36 BLB36 WL48 VDD VSS bitcell_6t
XC48_37 BL37 BLB37 WL48 VDD VSS bitcell_6t
XC48_38 BL38 BLB38 WL48 VDD VSS bitcell_6t
XC48_39 BL39 BLB39 WL48 VDD VSS bitcell_6t
XC48_40 BL40 BLB40 WL48 VDD VSS bitcell_6t
XC48_41 BL41 BLB41 WL48 VDD VSS bitcell_6t
XC48_42 BL42 BLB42 WL48 VDD VSS bitcell_6t
XC48_43 BL43 BLB43 WL48 VDD VSS bitcell_6t
XC48_44 BL44 BLB44 WL48 VDD VSS bitcell_6t
XC48_45 BL45 BLB45 WL48 VDD VSS bitcell_6t
XC48_46 BL46 BLB46 WL48 VDD VSS bitcell_6t
XC48_47 BL47 BLB47 WL48 VDD VSS bitcell_6t
XC48_48 BL48 BLB48 WL48 VDD VSS bitcell_6t
XC48_49 BL49 BLB49 WL48 VDD VSS bitcell_6t
XC48_50 BL50 BLB50 WL48 VDD VSS bitcell_6t
XC48_51 BL51 BLB51 WL48 VDD VSS bitcell_6t
XC48_52 BL52 BLB52 WL48 VDD VSS bitcell_6t
XC48_53 BL53 BLB53 WL48 VDD VSS bitcell_6t
XC48_54 BL54 BLB54 WL48 VDD VSS bitcell_6t
XC48_55 BL55 BLB55 WL48 VDD VSS bitcell_6t
XC48_56 BL56 BLB56 WL48 VDD VSS bitcell_6t
XC48_57 BL57 BLB57 WL48 VDD VSS bitcell_6t
XC48_58 BL58 BLB58 WL48 VDD VSS bitcell_6t
XC48_59 BL59 BLB59 WL48 VDD VSS bitcell_6t
XC48_60 BL60 BLB60 WL48 VDD VSS bitcell_6t
XC48_61 BL61 BLB61 WL48 VDD VSS bitcell_6t
XC48_62 BL62 BLB62 WL48 VDD VSS bitcell_6t
XC48_63 BL63 BLB63 WL48 VDD VSS bitcell_6t
XC48_64 BL64 BLB64 WL48 VDD VSS bitcell_6t
XC48_65 BL65 BLB65 WL48 VDD VSS bitcell_6t
XC48_66 BL66 BLB66 WL48 VDD VSS bitcell_6t
XC48_67 BL67 BLB67 WL48 VDD VSS bitcell_6t
XC48_68 BL68 BLB68 WL48 VDD VSS bitcell_6t
XC48_69 BL69 BLB69 WL48 VDD VSS bitcell_6t
XC48_70 BL70 BLB70 WL48 VDD VSS bitcell_6t
XC48_71 BL71 BLB71 WL48 VDD VSS bitcell_6t
XC48_72 BL72 BLB72 WL48 VDD VSS bitcell_6t
XC48_73 BL73 BLB73 WL48 VDD VSS bitcell_6t
XC48_74 BL74 BLB74 WL48 VDD VSS bitcell_6t
XC48_75 BL75 BLB75 WL48 VDD VSS bitcell_6t
XC48_76 BL76 BLB76 WL48 VDD VSS bitcell_6t
XC48_77 BL77 BLB77 WL48 VDD VSS bitcell_6t
XC48_78 BL78 BLB78 WL48 VDD VSS bitcell_6t
XC48_79 BL79 BLB79 WL48 VDD VSS bitcell_6t
XC48_80 BL80 BLB80 WL48 VDD VSS bitcell_6t
XC48_81 BL81 BLB81 WL48 VDD VSS bitcell_6t
XC48_82 BL82 BLB82 WL48 VDD VSS bitcell_6t
XC48_83 BL83 BLB83 WL48 VDD VSS bitcell_6t
XC48_84 BL84 BLB84 WL48 VDD VSS bitcell_6t
XC48_85 BL85 BLB85 WL48 VDD VSS bitcell_6t
XC48_86 BL86 BLB86 WL48 VDD VSS bitcell_6t
XC48_87 BL87 BLB87 WL48 VDD VSS bitcell_6t
XC48_88 BL88 BLB88 WL48 VDD VSS bitcell_6t
XC48_89 BL89 BLB89 WL48 VDD VSS bitcell_6t
XC48_90 BL90 BLB90 WL48 VDD VSS bitcell_6t
XC48_91 BL91 BLB91 WL48 VDD VSS bitcell_6t
XC48_92 BL92 BLB92 WL48 VDD VSS bitcell_6t
XC48_93 BL93 BLB93 WL48 VDD VSS bitcell_6t
XC48_94 BL94 BLB94 WL48 VDD VSS bitcell_6t
XC48_95 BL95 BLB95 WL48 VDD VSS bitcell_6t
XC48_96 BL96 BLB96 WL48 VDD VSS bitcell_6t
XC48_97 BL97 BLB97 WL48 VDD VSS bitcell_6t
XC48_98 BL98 BLB98 WL48 VDD VSS bitcell_6t
XC48_99 BL99 BLB99 WL48 VDD VSS bitcell_6t
XC48_100 BL100 BLB100 WL48 VDD VSS bitcell_6t
XC48_101 BL101 BLB101 WL48 VDD VSS bitcell_6t
XC48_102 BL102 BLB102 WL48 VDD VSS bitcell_6t
XC48_103 BL103 BLB103 WL48 VDD VSS bitcell_6t
XC48_104 BL104 BLB104 WL48 VDD VSS bitcell_6t
XC48_105 BL105 BLB105 WL48 VDD VSS bitcell_6t
XC48_106 BL106 BLB106 WL48 VDD VSS bitcell_6t
XC48_107 BL107 BLB107 WL48 VDD VSS bitcell_6t
XC48_108 BL108 BLB108 WL48 VDD VSS bitcell_6t
XC48_109 BL109 BLB109 WL48 VDD VSS bitcell_6t
XC48_110 BL110 BLB110 WL48 VDD VSS bitcell_6t
XC48_111 BL111 BLB111 WL48 VDD VSS bitcell_6t
XC48_112 BL112 BLB112 WL48 VDD VSS bitcell_6t
XC48_113 BL113 BLB113 WL48 VDD VSS bitcell_6t
XC48_114 BL114 BLB114 WL48 VDD VSS bitcell_6t
XC48_115 BL115 BLB115 WL48 VDD VSS bitcell_6t
XC48_116 BL116 BLB116 WL48 VDD VSS bitcell_6t
XC48_117 BL117 BLB117 WL48 VDD VSS bitcell_6t
XC48_118 BL118 BLB118 WL48 VDD VSS bitcell_6t
XC48_119 BL119 BLB119 WL48 VDD VSS bitcell_6t
XC48_120 BL120 BLB120 WL48 VDD VSS bitcell_6t
XC48_121 BL121 BLB121 WL48 VDD VSS bitcell_6t
XC48_122 BL122 BLB122 WL48 VDD VSS bitcell_6t
XC48_123 BL123 BLB123 WL48 VDD VSS bitcell_6t
XC48_124 BL124 BLB124 WL48 VDD VSS bitcell_6t
XC48_125 BL125 BLB125 WL48 VDD VSS bitcell_6t
XC48_126 BL126 BLB126 WL48 VDD VSS bitcell_6t
XC48_127 BL127 BLB127 WL48 VDD VSS bitcell_6t
XC49_0 BL0 BLB0 WL49 VDD VSS bitcell_6t
XC49_1 BL1 BLB1 WL49 VDD VSS bitcell_6t
XC49_2 BL2 BLB2 WL49 VDD VSS bitcell_6t
XC49_3 BL3 BLB3 WL49 VDD VSS bitcell_6t
XC49_4 BL4 BLB4 WL49 VDD VSS bitcell_6t
XC49_5 BL5 BLB5 WL49 VDD VSS bitcell_6t
XC49_6 BL6 BLB6 WL49 VDD VSS bitcell_6t
XC49_7 BL7 BLB7 WL49 VDD VSS bitcell_6t
XC49_8 BL8 BLB8 WL49 VDD VSS bitcell_6t
XC49_9 BL9 BLB9 WL49 VDD VSS bitcell_6t
XC49_10 BL10 BLB10 WL49 VDD VSS bitcell_6t
XC49_11 BL11 BLB11 WL49 VDD VSS bitcell_6t
XC49_12 BL12 BLB12 WL49 VDD VSS bitcell_6t
XC49_13 BL13 BLB13 WL49 VDD VSS bitcell_6t
XC49_14 BL14 BLB14 WL49 VDD VSS bitcell_6t
XC49_15 BL15 BLB15 WL49 VDD VSS bitcell_6t
XC49_16 BL16 BLB16 WL49 VDD VSS bitcell_6t
XC49_17 BL17 BLB17 WL49 VDD VSS bitcell_6t
XC49_18 BL18 BLB18 WL49 VDD VSS bitcell_6t
XC49_19 BL19 BLB19 WL49 VDD VSS bitcell_6t
XC49_20 BL20 BLB20 WL49 VDD VSS bitcell_6t
XC49_21 BL21 BLB21 WL49 VDD VSS bitcell_6t
XC49_22 BL22 BLB22 WL49 VDD VSS bitcell_6t
XC49_23 BL23 BLB23 WL49 VDD VSS bitcell_6t
XC49_24 BL24 BLB24 WL49 VDD VSS bitcell_6t
XC49_25 BL25 BLB25 WL49 VDD VSS bitcell_6t
XC49_26 BL26 BLB26 WL49 VDD VSS bitcell_6t
XC49_27 BL27 BLB27 WL49 VDD VSS bitcell_6t
XC49_28 BL28 BLB28 WL49 VDD VSS bitcell_6t
XC49_29 BL29 BLB29 WL49 VDD VSS bitcell_6t
XC49_30 BL30 BLB30 WL49 VDD VSS bitcell_6t
XC49_31 BL31 BLB31 WL49 VDD VSS bitcell_6t
XC49_32 BL32 BLB32 WL49 VDD VSS bitcell_6t
XC49_33 BL33 BLB33 WL49 VDD VSS bitcell_6t
XC49_34 BL34 BLB34 WL49 VDD VSS bitcell_6t
XC49_35 BL35 BLB35 WL49 VDD VSS bitcell_6t
XC49_36 BL36 BLB36 WL49 VDD VSS bitcell_6t
XC49_37 BL37 BLB37 WL49 VDD VSS bitcell_6t
XC49_38 BL38 BLB38 WL49 VDD VSS bitcell_6t
XC49_39 BL39 BLB39 WL49 VDD VSS bitcell_6t
XC49_40 BL40 BLB40 WL49 VDD VSS bitcell_6t
XC49_41 BL41 BLB41 WL49 VDD VSS bitcell_6t
XC49_42 BL42 BLB42 WL49 VDD VSS bitcell_6t
XC49_43 BL43 BLB43 WL49 VDD VSS bitcell_6t
XC49_44 BL44 BLB44 WL49 VDD VSS bitcell_6t
XC49_45 BL45 BLB45 WL49 VDD VSS bitcell_6t
XC49_46 BL46 BLB46 WL49 VDD VSS bitcell_6t
XC49_47 BL47 BLB47 WL49 VDD VSS bitcell_6t
XC49_48 BL48 BLB48 WL49 VDD VSS bitcell_6t
XC49_49 BL49 BLB49 WL49 VDD VSS bitcell_6t
XC49_50 BL50 BLB50 WL49 VDD VSS bitcell_6t
XC49_51 BL51 BLB51 WL49 VDD VSS bitcell_6t
XC49_52 BL52 BLB52 WL49 VDD VSS bitcell_6t
XC49_53 BL53 BLB53 WL49 VDD VSS bitcell_6t
XC49_54 BL54 BLB54 WL49 VDD VSS bitcell_6t
XC49_55 BL55 BLB55 WL49 VDD VSS bitcell_6t
XC49_56 BL56 BLB56 WL49 VDD VSS bitcell_6t
XC49_57 BL57 BLB57 WL49 VDD VSS bitcell_6t
XC49_58 BL58 BLB58 WL49 VDD VSS bitcell_6t
XC49_59 BL59 BLB59 WL49 VDD VSS bitcell_6t
XC49_60 BL60 BLB60 WL49 VDD VSS bitcell_6t
XC49_61 BL61 BLB61 WL49 VDD VSS bitcell_6t
XC49_62 BL62 BLB62 WL49 VDD VSS bitcell_6t
XC49_63 BL63 BLB63 WL49 VDD VSS bitcell_6t
XC49_64 BL64 BLB64 WL49 VDD VSS bitcell_6t
XC49_65 BL65 BLB65 WL49 VDD VSS bitcell_6t
XC49_66 BL66 BLB66 WL49 VDD VSS bitcell_6t
XC49_67 BL67 BLB67 WL49 VDD VSS bitcell_6t
XC49_68 BL68 BLB68 WL49 VDD VSS bitcell_6t
XC49_69 BL69 BLB69 WL49 VDD VSS bitcell_6t
XC49_70 BL70 BLB70 WL49 VDD VSS bitcell_6t
XC49_71 BL71 BLB71 WL49 VDD VSS bitcell_6t
XC49_72 BL72 BLB72 WL49 VDD VSS bitcell_6t
XC49_73 BL73 BLB73 WL49 VDD VSS bitcell_6t
XC49_74 BL74 BLB74 WL49 VDD VSS bitcell_6t
XC49_75 BL75 BLB75 WL49 VDD VSS bitcell_6t
XC49_76 BL76 BLB76 WL49 VDD VSS bitcell_6t
XC49_77 BL77 BLB77 WL49 VDD VSS bitcell_6t
XC49_78 BL78 BLB78 WL49 VDD VSS bitcell_6t
XC49_79 BL79 BLB79 WL49 VDD VSS bitcell_6t
XC49_80 BL80 BLB80 WL49 VDD VSS bitcell_6t
XC49_81 BL81 BLB81 WL49 VDD VSS bitcell_6t
XC49_82 BL82 BLB82 WL49 VDD VSS bitcell_6t
XC49_83 BL83 BLB83 WL49 VDD VSS bitcell_6t
XC49_84 BL84 BLB84 WL49 VDD VSS bitcell_6t
XC49_85 BL85 BLB85 WL49 VDD VSS bitcell_6t
XC49_86 BL86 BLB86 WL49 VDD VSS bitcell_6t
XC49_87 BL87 BLB87 WL49 VDD VSS bitcell_6t
XC49_88 BL88 BLB88 WL49 VDD VSS bitcell_6t
XC49_89 BL89 BLB89 WL49 VDD VSS bitcell_6t
XC49_90 BL90 BLB90 WL49 VDD VSS bitcell_6t
XC49_91 BL91 BLB91 WL49 VDD VSS bitcell_6t
XC49_92 BL92 BLB92 WL49 VDD VSS bitcell_6t
XC49_93 BL93 BLB93 WL49 VDD VSS bitcell_6t
XC49_94 BL94 BLB94 WL49 VDD VSS bitcell_6t
XC49_95 BL95 BLB95 WL49 VDD VSS bitcell_6t
XC49_96 BL96 BLB96 WL49 VDD VSS bitcell_6t
XC49_97 BL97 BLB97 WL49 VDD VSS bitcell_6t
XC49_98 BL98 BLB98 WL49 VDD VSS bitcell_6t
XC49_99 BL99 BLB99 WL49 VDD VSS bitcell_6t
XC49_100 BL100 BLB100 WL49 VDD VSS bitcell_6t
XC49_101 BL101 BLB101 WL49 VDD VSS bitcell_6t
XC49_102 BL102 BLB102 WL49 VDD VSS bitcell_6t
XC49_103 BL103 BLB103 WL49 VDD VSS bitcell_6t
XC49_104 BL104 BLB104 WL49 VDD VSS bitcell_6t
XC49_105 BL105 BLB105 WL49 VDD VSS bitcell_6t
XC49_106 BL106 BLB106 WL49 VDD VSS bitcell_6t
XC49_107 BL107 BLB107 WL49 VDD VSS bitcell_6t
XC49_108 BL108 BLB108 WL49 VDD VSS bitcell_6t
XC49_109 BL109 BLB109 WL49 VDD VSS bitcell_6t
XC49_110 BL110 BLB110 WL49 VDD VSS bitcell_6t
XC49_111 BL111 BLB111 WL49 VDD VSS bitcell_6t
XC49_112 BL112 BLB112 WL49 VDD VSS bitcell_6t
XC49_113 BL113 BLB113 WL49 VDD VSS bitcell_6t
XC49_114 BL114 BLB114 WL49 VDD VSS bitcell_6t
XC49_115 BL115 BLB115 WL49 VDD VSS bitcell_6t
XC49_116 BL116 BLB116 WL49 VDD VSS bitcell_6t
XC49_117 BL117 BLB117 WL49 VDD VSS bitcell_6t
XC49_118 BL118 BLB118 WL49 VDD VSS bitcell_6t
XC49_119 BL119 BLB119 WL49 VDD VSS bitcell_6t
XC49_120 BL120 BLB120 WL49 VDD VSS bitcell_6t
XC49_121 BL121 BLB121 WL49 VDD VSS bitcell_6t
XC49_122 BL122 BLB122 WL49 VDD VSS bitcell_6t
XC49_123 BL123 BLB123 WL49 VDD VSS bitcell_6t
XC49_124 BL124 BLB124 WL49 VDD VSS bitcell_6t
XC49_125 BL125 BLB125 WL49 VDD VSS bitcell_6t
XC49_126 BL126 BLB126 WL49 VDD VSS bitcell_6t
XC49_127 BL127 BLB127 WL49 VDD VSS bitcell_6t
XC50_0 BL0 BLB0 WL50 VDD VSS bitcell_6t
XC50_1 BL1 BLB1 WL50 VDD VSS bitcell_6t
XC50_2 BL2 BLB2 WL50 VDD VSS bitcell_6t
XC50_3 BL3 BLB3 WL50 VDD VSS bitcell_6t
XC50_4 BL4 BLB4 WL50 VDD VSS bitcell_6t
XC50_5 BL5 BLB5 WL50 VDD VSS bitcell_6t
XC50_6 BL6 BLB6 WL50 VDD VSS bitcell_6t
XC50_7 BL7 BLB7 WL50 VDD VSS bitcell_6t
XC50_8 BL8 BLB8 WL50 VDD VSS bitcell_6t
XC50_9 BL9 BLB9 WL50 VDD VSS bitcell_6t
XC50_10 BL10 BLB10 WL50 VDD VSS bitcell_6t
XC50_11 BL11 BLB11 WL50 VDD VSS bitcell_6t
XC50_12 BL12 BLB12 WL50 VDD VSS bitcell_6t
XC50_13 BL13 BLB13 WL50 VDD VSS bitcell_6t
XC50_14 BL14 BLB14 WL50 VDD VSS bitcell_6t
XC50_15 BL15 BLB15 WL50 VDD VSS bitcell_6t
XC50_16 BL16 BLB16 WL50 VDD VSS bitcell_6t
XC50_17 BL17 BLB17 WL50 VDD VSS bitcell_6t
XC50_18 BL18 BLB18 WL50 VDD VSS bitcell_6t
XC50_19 BL19 BLB19 WL50 VDD VSS bitcell_6t
XC50_20 BL20 BLB20 WL50 VDD VSS bitcell_6t
XC50_21 BL21 BLB21 WL50 VDD VSS bitcell_6t
XC50_22 BL22 BLB22 WL50 VDD VSS bitcell_6t
XC50_23 BL23 BLB23 WL50 VDD VSS bitcell_6t
XC50_24 BL24 BLB24 WL50 VDD VSS bitcell_6t
XC50_25 BL25 BLB25 WL50 VDD VSS bitcell_6t
XC50_26 BL26 BLB26 WL50 VDD VSS bitcell_6t
XC50_27 BL27 BLB27 WL50 VDD VSS bitcell_6t
XC50_28 BL28 BLB28 WL50 VDD VSS bitcell_6t
XC50_29 BL29 BLB29 WL50 VDD VSS bitcell_6t
XC50_30 BL30 BLB30 WL50 VDD VSS bitcell_6t
XC50_31 BL31 BLB31 WL50 VDD VSS bitcell_6t
XC50_32 BL32 BLB32 WL50 VDD VSS bitcell_6t
XC50_33 BL33 BLB33 WL50 VDD VSS bitcell_6t
XC50_34 BL34 BLB34 WL50 VDD VSS bitcell_6t
XC50_35 BL35 BLB35 WL50 VDD VSS bitcell_6t
XC50_36 BL36 BLB36 WL50 VDD VSS bitcell_6t
XC50_37 BL37 BLB37 WL50 VDD VSS bitcell_6t
XC50_38 BL38 BLB38 WL50 VDD VSS bitcell_6t
XC50_39 BL39 BLB39 WL50 VDD VSS bitcell_6t
XC50_40 BL40 BLB40 WL50 VDD VSS bitcell_6t
XC50_41 BL41 BLB41 WL50 VDD VSS bitcell_6t
XC50_42 BL42 BLB42 WL50 VDD VSS bitcell_6t
XC50_43 BL43 BLB43 WL50 VDD VSS bitcell_6t
XC50_44 BL44 BLB44 WL50 VDD VSS bitcell_6t
XC50_45 BL45 BLB45 WL50 VDD VSS bitcell_6t
XC50_46 BL46 BLB46 WL50 VDD VSS bitcell_6t
XC50_47 BL47 BLB47 WL50 VDD VSS bitcell_6t
XC50_48 BL48 BLB48 WL50 VDD VSS bitcell_6t
XC50_49 BL49 BLB49 WL50 VDD VSS bitcell_6t
XC50_50 BL50 BLB50 WL50 VDD VSS bitcell_6t
XC50_51 BL51 BLB51 WL50 VDD VSS bitcell_6t
XC50_52 BL52 BLB52 WL50 VDD VSS bitcell_6t
XC50_53 BL53 BLB53 WL50 VDD VSS bitcell_6t
XC50_54 BL54 BLB54 WL50 VDD VSS bitcell_6t
XC50_55 BL55 BLB55 WL50 VDD VSS bitcell_6t
XC50_56 BL56 BLB56 WL50 VDD VSS bitcell_6t
XC50_57 BL57 BLB57 WL50 VDD VSS bitcell_6t
XC50_58 BL58 BLB58 WL50 VDD VSS bitcell_6t
XC50_59 BL59 BLB59 WL50 VDD VSS bitcell_6t
XC50_60 BL60 BLB60 WL50 VDD VSS bitcell_6t
XC50_61 BL61 BLB61 WL50 VDD VSS bitcell_6t
XC50_62 BL62 BLB62 WL50 VDD VSS bitcell_6t
XC50_63 BL63 BLB63 WL50 VDD VSS bitcell_6t
XC50_64 BL64 BLB64 WL50 VDD VSS bitcell_6t
XC50_65 BL65 BLB65 WL50 VDD VSS bitcell_6t
XC50_66 BL66 BLB66 WL50 VDD VSS bitcell_6t
XC50_67 BL67 BLB67 WL50 VDD VSS bitcell_6t
XC50_68 BL68 BLB68 WL50 VDD VSS bitcell_6t
XC50_69 BL69 BLB69 WL50 VDD VSS bitcell_6t
XC50_70 BL70 BLB70 WL50 VDD VSS bitcell_6t
XC50_71 BL71 BLB71 WL50 VDD VSS bitcell_6t
XC50_72 BL72 BLB72 WL50 VDD VSS bitcell_6t
XC50_73 BL73 BLB73 WL50 VDD VSS bitcell_6t
XC50_74 BL74 BLB74 WL50 VDD VSS bitcell_6t
XC50_75 BL75 BLB75 WL50 VDD VSS bitcell_6t
XC50_76 BL76 BLB76 WL50 VDD VSS bitcell_6t
XC50_77 BL77 BLB77 WL50 VDD VSS bitcell_6t
XC50_78 BL78 BLB78 WL50 VDD VSS bitcell_6t
XC50_79 BL79 BLB79 WL50 VDD VSS bitcell_6t
XC50_80 BL80 BLB80 WL50 VDD VSS bitcell_6t
XC50_81 BL81 BLB81 WL50 VDD VSS bitcell_6t
XC50_82 BL82 BLB82 WL50 VDD VSS bitcell_6t
XC50_83 BL83 BLB83 WL50 VDD VSS bitcell_6t
XC50_84 BL84 BLB84 WL50 VDD VSS bitcell_6t
XC50_85 BL85 BLB85 WL50 VDD VSS bitcell_6t
XC50_86 BL86 BLB86 WL50 VDD VSS bitcell_6t
XC50_87 BL87 BLB87 WL50 VDD VSS bitcell_6t
XC50_88 BL88 BLB88 WL50 VDD VSS bitcell_6t
XC50_89 BL89 BLB89 WL50 VDD VSS bitcell_6t
XC50_90 BL90 BLB90 WL50 VDD VSS bitcell_6t
XC50_91 BL91 BLB91 WL50 VDD VSS bitcell_6t
XC50_92 BL92 BLB92 WL50 VDD VSS bitcell_6t
XC50_93 BL93 BLB93 WL50 VDD VSS bitcell_6t
XC50_94 BL94 BLB94 WL50 VDD VSS bitcell_6t
XC50_95 BL95 BLB95 WL50 VDD VSS bitcell_6t
XC50_96 BL96 BLB96 WL50 VDD VSS bitcell_6t
XC50_97 BL97 BLB97 WL50 VDD VSS bitcell_6t
XC50_98 BL98 BLB98 WL50 VDD VSS bitcell_6t
XC50_99 BL99 BLB99 WL50 VDD VSS bitcell_6t
XC50_100 BL100 BLB100 WL50 VDD VSS bitcell_6t
XC50_101 BL101 BLB101 WL50 VDD VSS bitcell_6t
XC50_102 BL102 BLB102 WL50 VDD VSS bitcell_6t
XC50_103 BL103 BLB103 WL50 VDD VSS bitcell_6t
XC50_104 BL104 BLB104 WL50 VDD VSS bitcell_6t
XC50_105 BL105 BLB105 WL50 VDD VSS bitcell_6t
XC50_106 BL106 BLB106 WL50 VDD VSS bitcell_6t
XC50_107 BL107 BLB107 WL50 VDD VSS bitcell_6t
XC50_108 BL108 BLB108 WL50 VDD VSS bitcell_6t
XC50_109 BL109 BLB109 WL50 VDD VSS bitcell_6t
XC50_110 BL110 BLB110 WL50 VDD VSS bitcell_6t
XC50_111 BL111 BLB111 WL50 VDD VSS bitcell_6t
XC50_112 BL112 BLB112 WL50 VDD VSS bitcell_6t
XC50_113 BL113 BLB113 WL50 VDD VSS bitcell_6t
XC50_114 BL114 BLB114 WL50 VDD VSS bitcell_6t
XC50_115 BL115 BLB115 WL50 VDD VSS bitcell_6t
XC50_116 BL116 BLB116 WL50 VDD VSS bitcell_6t
XC50_117 BL117 BLB117 WL50 VDD VSS bitcell_6t
XC50_118 BL118 BLB118 WL50 VDD VSS bitcell_6t
XC50_119 BL119 BLB119 WL50 VDD VSS bitcell_6t
XC50_120 BL120 BLB120 WL50 VDD VSS bitcell_6t
XC50_121 BL121 BLB121 WL50 VDD VSS bitcell_6t
XC50_122 BL122 BLB122 WL50 VDD VSS bitcell_6t
XC50_123 BL123 BLB123 WL50 VDD VSS bitcell_6t
XC50_124 BL124 BLB124 WL50 VDD VSS bitcell_6t
XC50_125 BL125 BLB125 WL50 VDD VSS bitcell_6t
XC50_126 BL126 BLB126 WL50 VDD VSS bitcell_6t
XC50_127 BL127 BLB127 WL50 VDD VSS bitcell_6t
XC51_0 BL0 BLB0 WL51 VDD VSS bitcell_6t
XC51_1 BL1 BLB1 WL51 VDD VSS bitcell_6t
XC51_2 BL2 BLB2 WL51 VDD VSS bitcell_6t
XC51_3 BL3 BLB3 WL51 VDD VSS bitcell_6t
XC51_4 BL4 BLB4 WL51 VDD VSS bitcell_6t
XC51_5 BL5 BLB5 WL51 VDD VSS bitcell_6t
XC51_6 BL6 BLB6 WL51 VDD VSS bitcell_6t
XC51_7 BL7 BLB7 WL51 VDD VSS bitcell_6t
XC51_8 BL8 BLB8 WL51 VDD VSS bitcell_6t
XC51_9 BL9 BLB9 WL51 VDD VSS bitcell_6t
XC51_10 BL10 BLB10 WL51 VDD VSS bitcell_6t
XC51_11 BL11 BLB11 WL51 VDD VSS bitcell_6t
XC51_12 BL12 BLB12 WL51 VDD VSS bitcell_6t
XC51_13 BL13 BLB13 WL51 VDD VSS bitcell_6t
XC51_14 BL14 BLB14 WL51 VDD VSS bitcell_6t
XC51_15 BL15 BLB15 WL51 VDD VSS bitcell_6t
XC51_16 BL16 BLB16 WL51 VDD VSS bitcell_6t
XC51_17 BL17 BLB17 WL51 VDD VSS bitcell_6t
XC51_18 BL18 BLB18 WL51 VDD VSS bitcell_6t
XC51_19 BL19 BLB19 WL51 VDD VSS bitcell_6t
XC51_20 BL20 BLB20 WL51 VDD VSS bitcell_6t
XC51_21 BL21 BLB21 WL51 VDD VSS bitcell_6t
XC51_22 BL22 BLB22 WL51 VDD VSS bitcell_6t
XC51_23 BL23 BLB23 WL51 VDD VSS bitcell_6t
XC51_24 BL24 BLB24 WL51 VDD VSS bitcell_6t
XC51_25 BL25 BLB25 WL51 VDD VSS bitcell_6t
XC51_26 BL26 BLB26 WL51 VDD VSS bitcell_6t
XC51_27 BL27 BLB27 WL51 VDD VSS bitcell_6t
XC51_28 BL28 BLB28 WL51 VDD VSS bitcell_6t
XC51_29 BL29 BLB29 WL51 VDD VSS bitcell_6t
XC51_30 BL30 BLB30 WL51 VDD VSS bitcell_6t
XC51_31 BL31 BLB31 WL51 VDD VSS bitcell_6t
XC51_32 BL32 BLB32 WL51 VDD VSS bitcell_6t
XC51_33 BL33 BLB33 WL51 VDD VSS bitcell_6t
XC51_34 BL34 BLB34 WL51 VDD VSS bitcell_6t
XC51_35 BL35 BLB35 WL51 VDD VSS bitcell_6t
XC51_36 BL36 BLB36 WL51 VDD VSS bitcell_6t
XC51_37 BL37 BLB37 WL51 VDD VSS bitcell_6t
XC51_38 BL38 BLB38 WL51 VDD VSS bitcell_6t
XC51_39 BL39 BLB39 WL51 VDD VSS bitcell_6t
XC51_40 BL40 BLB40 WL51 VDD VSS bitcell_6t
XC51_41 BL41 BLB41 WL51 VDD VSS bitcell_6t
XC51_42 BL42 BLB42 WL51 VDD VSS bitcell_6t
XC51_43 BL43 BLB43 WL51 VDD VSS bitcell_6t
XC51_44 BL44 BLB44 WL51 VDD VSS bitcell_6t
XC51_45 BL45 BLB45 WL51 VDD VSS bitcell_6t
XC51_46 BL46 BLB46 WL51 VDD VSS bitcell_6t
XC51_47 BL47 BLB47 WL51 VDD VSS bitcell_6t
XC51_48 BL48 BLB48 WL51 VDD VSS bitcell_6t
XC51_49 BL49 BLB49 WL51 VDD VSS bitcell_6t
XC51_50 BL50 BLB50 WL51 VDD VSS bitcell_6t
XC51_51 BL51 BLB51 WL51 VDD VSS bitcell_6t
XC51_52 BL52 BLB52 WL51 VDD VSS bitcell_6t
XC51_53 BL53 BLB53 WL51 VDD VSS bitcell_6t
XC51_54 BL54 BLB54 WL51 VDD VSS bitcell_6t
XC51_55 BL55 BLB55 WL51 VDD VSS bitcell_6t
XC51_56 BL56 BLB56 WL51 VDD VSS bitcell_6t
XC51_57 BL57 BLB57 WL51 VDD VSS bitcell_6t
XC51_58 BL58 BLB58 WL51 VDD VSS bitcell_6t
XC51_59 BL59 BLB59 WL51 VDD VSS bitcell_6t
XC51_60 BL60 BLB60 WL51 VDD VSS bitcell_6t
XC51_61 BL61 BLB61 WL51 VDD VSS bitcell_6t
XC51_62 BL62 BLB62 WL51 VDD VSS bitcell_6t
XC51_63 BL63 BLB63 WL51 VDD VSS bitcell_6t
XC51_64 BL64 BLB64 WL51 VDD VSS bitcell_6t
XC51_65 BL65 BLB65 WL51 VDD VSS bitcell_6t
XC51_66 BL66 BLB66 WL51 VDD VSS bitcell_6t
XC51_67 BL67 BLB67 WL51 VDD VSS bitcell_6t
XC51_68 BL68 BLB68 WL51 VDD VSS bitcell_6t
XC51_69 BL69 BLB69 WL51 VDD VSS bitcell_6t
XC51_70 BL70 BLB70 WL51 VDD VSS bitcell_6t
XC51_71 BL71 BLB71 WL51 VDD VSS bitcell_6t
XC51_72 BL72 BLB72 WL51 VDD VSS bitcell_6t
XC51_73 BL73 BLB73 WL51 VDD VSS bitcell_6t
XC51_74 BL74 BLB74 WL51 VDD VSS bitcell_6t
XC51_75 BL75 BLB75 WL51 VDD VSS bitcell_6t
XC51_76 BL76 BLB76 WL51 VDD VSS bitcell_6t
XC51_77 BL77 BLB77 WL51 VDD VSS bitcell_6t
XC51_78 BL78 BLB78 WL51 VDD VSS bitcell_6t
XC51_79 BL79 BLB79 WL51 VDD VSS bitcell_6t
XC51_80 BL80 BLB80 WL51 VDD VSS bitcell_6t
XC51_81 BL81 BLB81 WL51 VDD VSS bitcell_6t
XC51_82 BL82 BLB82 WL51 VDD VSS bitcell_6t
XC51_83 BL83 BLB83 WL51 VDD VSS bitcell_6t
XC51_84 BL84 BLB84 WL51 VDD VSS bitcell_6t
XC51_85 BL85 BLB85 WL51 VDD VSS bitcell_6t
XC51_86 BL86 BLB86 WL51 VDD VSS bitcell_6t
XC51_87 BL87 BLB87 WL51 VDD VSS bitcell_6t
XC51_88 BL88 BLB88 WL51 VDD VSS bitcell_6t
XC51_89 BL89 BLB89 WL51 VDD VSS bitcell_6t
XC51_90 BL90 BLB90 WL51 VDD VSS bitcell_6t
XC51_91 BL91 BLB91 WL51 VDD VSS bitcell_6t
XC51_92 BL92 BLB92 WL51 VDD VSS bitcell_6t
XC51_93 BL93 BLB93 WL51 VDD VSS bitcell_6t
XC51_94 BL94 BLB94 WL51 VDD VSS bitcell_6t
XC51_95 BL95 BLB95 WL51 VDD VSS bitcell_6t
XC51_96 BL96 BLB96 WL51 VDD VSS bitcell_6t
XC51_97 BL97 BLB97 WL51 VDD VSS bitcell_6t
XC51_98 BL98 BLB98 WL51 VDD VSS bitcell_6t
XC51_99 BL99 BLB99 WL51 VDD VSS bitcell_6t
XC51_100 BL100 BLB100 WL51 VDD VSS bitcell_6t
XC51_101 BL101 BLB101 WL51 VDD VSS bitcell_6t
XC51_102 BL102 BLB102 WL51 VDD VSS bitcell_6t
XC51_103 BL103 BLB103 WL51 VDD VSS bitcell_6t
XC51_104 BL104 BLB104 WL51 VDD VSS bitcell_6t
XC51_105 BL105 BLB105 WL51 VDD VSS bitcell_6t
XC51_106 BL106 BLB106 WL51 VDD VSS bitcell_6t
XC51_107 BL107 BLB107 WL51 VDD VSS bitcell_6t
XC51_108 BL108 BLB108 WL51 VDD VSS bitcell_6t
XC51_109 BL109 BLB109 WL51 VDD VSS bitcell_6t
XC51_110 BL110 BLB110 WL51 VDD VSS bitcell_6t
XC51_111 BL111 BLB111 WL51 VDD VSS bitcell_6t
XC51_112 BL112 BLB112 WL51 VDD VSS bitcell_6t
XC51_113 BL113 BLB113 WL51 VDD VSS bitcell_6t
XC51_114 BL114 BLB114 WL51 VDD VSS bitcell_6t
XC51_115 BL115 BLB115 WL51 VDD VSS bitcell_6t
XC51_116 BL116 BLB116 WL51 VDD VSS bitcell_6t
XC51_117 BL117 BLB117 WL51 VDD VSS bitcell_6t
XC51_118 BL118 BLB118 WL51 VDD VSS bitcell_6t
XC51_119 BL119 BLB119 WL51 VDD VSS bitcell_6t
XC51_120 BL120 BLB120 WL51 VDD VSS bitcell_6t
XC51_121 BL121 BLB121 WL51 VDD VSS bitcell_6t
XC51_122 BL122 BLB122 WL51 VDD VSS bitcell_6t
XC51_123 BL123 BLB123 WL51 VDD VSS bitcell_6t
XC51_124 BL124 BLB124 WL51 VDD VSS bitcell_6t
XC51_125 BL125 BLB125 WL51 VDD VSS bitcell_6t
XC51_126 BL126 BLB126 WL51 VDD VSS bitcell_6t
XC51_127 BL127 BLB127 WL51 VDD VSS bitcell_6t
XC52_0 BL0 BLB0 WL52 VDD VSS bitcell_6t
XC52_1 BL1 BLB1 WL52 VDD VSS bitcell_6t
XC52_2 BL2 BLB2 WL52 VDD VSS bitcell_6t
XC52_3 BL3 BLB3 WL52 VDD VSS bitcell_6t
XC52_4 BL4 BLB4 WL52 VDD VSS bitcell_6t
XC52_5 BL5 BLB5 WL52 VDD VSS bitcell_6t
XC52_6 BL6 BLB6 WL52 VDD VSS bitcell_6t
XC52_7 BL7 BLB7 WL52 VDD VSS bitcell_6t
XC52_8 BL8 BLB8 WL52 VDD VSS bitcell_6t
XC52_9 BL9 BLB9 WL52 VDD VSS bitcell_6t
XC52_10 BL10 BLB10 WL52 VDD VSS bitcell_6t
XC52_11 BL11 BLB11 WL52 VDD VSS bitcell_6t
XC52_12 BL12 BLB12 WL52 VDD VSS bitcell_6t
XC52_13 BL13 BLB13 WL52 VDD VSS bitcell_6t
XC52_14 BL14 BLB14 WL52 VDD VSS bitcell_6t
XC52_15 BL15 BLB15 WL52 VDD VSS bitcell_6t
XC52_16 BL16 BLB16 WL52 VDD VSS bitcell_6t
XC52_17 BL17 BLB17 WL52 VDD VSS bitcell_6t
XC52_18 BL18 BLB18 WL52 VDD VSS bitcell_6t
XC52_19 BL19 BLB19 WL52 VDD VSS bitcell_6t
XC52_20 BL20 BLB20 WL52 VDD VSS bitcell_6t
XC52_21 BL21 BLB21 WL52 VDD VSS bitcell_6t
XC52_22 BL22 BLB22 WL52 VDD VSS bitcell_6t
XC52_23 BL23 BLB23 WL52 VDD VSS bitcell_6t
XC52_24 BL24 BLB24 WL52 VDD VSS bitcell_6t
XC52_25 BL25 BLB25 WL52 VDD VSS bitcell_6t
XC52_26 BL26 BLB26 WL52 VDD VSS bitcell_6t
XC52_27 BL27 BLB27 WL52 VDD VSS bitcell_6t
XC52_28 BL28 BLB28 WL52 VDD VSS bitcell_6t
XC52_29 BL29 BLB29 WL52 VDD VSS bitcell_6t
XC52_30 BL30 BLB30 WL52 VDD VSS bitcell_6t
XC52_31 BL31 BLB31 WL52 VDD VSS bitcell_6t
XC52_32 BL32 BLB32 WL52 VDD VSS bitcell_6t
XC52_33 BL33 BLB33 WL52 VDD VSS bitcell_6t
XC52_34 BL34 BLB34 WL52 VDD VSS bitcell_6t
XC52_35 BL35 BLB35 WL52 VDD VSS bitcell_6t
XC52_36 BL36 BLB36 WL52 VDD VSS bitcell_6t
XC52_37 BL37 BLB37 WL52 VDD VSS bitcell_6t
XC52_38 BL38 BLB38 WL52 VDD VSS bitcell_6t
XC52_39 BL39 BLB39 WL52 VDD VSS bitcell_6t
XC52_40 BL40 BLB40 WL52 VDD VSS bitcell_6t
XC52_41 BL41 BLB41 WL52 VDD VSS bitcell_6t
XC52_42 BL42 BLB42 WL52 VDD VSS bitcell_6t
XC52_43 BL43 BLB43 WL52 VDD VSS bitcell_6t
XC52_44 BL44 BLB44 WL52 VDD VSS bitcell_6t
XC52_45 BL45 BLB45 WL52 VDD VSS bitcell_6t
XC52_46 BL46 BLB46 WL52 VDD VSS bitcell_6t
XC52_47 BL47 BLB47 WL52 VDD VSS bitcell_6t
XC52_48 BL48 BLB48 WL52 VDD VSS bitcell_6t
XC52_49 BL49 BLB49 WL52 VDD VSS bitcell_6t
XC52_50 BL50 BLB50 WL52 VDD VSS bitcell_6t
XC52_51 BL51 BLB51 WL52 VDD VSS bitcell_6t
XC52_52 BL52 BLB52 WL52 VDD VSS bitcell_6t
XC52_53 BL53 BLB53 WL52 VDD VSS bitcell_6t
XC52_54 BL54 BLB54 WL52 VDD VSS bitcell_6t
XC52_55 BL55 BLB55 WL52 VDD VSS bitcell_6t
XC52_56 BL56 BLB56 WL52 VDD VSS bitcell_6t
XC52_57 BL57 BLB57 WL52 VDD VSS bitcell_6t
XC52_58 BL58 BLB58 WL52 VDD VSS bitcell_6t
XC52_59 BL59 BLB59 WL52 VDD VSS bitcell_6t
XC52_60 BL60 BLB60 WL52 VDD VSS bitcell_6t
XC52_61 BL61 BLB61 WL52 VDD VSS bitcell_6t
XC52_62 BL62 BLB62 WL52 VDD VSS bitcell_6t
XC52_63 BL63 BLB63 WL52 VDD VSS bitcell_6t
XC52_64 BL64 BLB64 WL52 VDD VSS bitcell_6t
XC52_65 BL65 BLB65 WL52 VDD VSS bitcell_6t
XC52_66 BL66 BLB66 WL52 VDD VSS bitcell_6t
XC52_67 BL67 BLB67 WL52 VDD VSS bitcell_6t
XC52_68 BL68 BLB68 WL52 VDD VSS bitcell_6t
XC52_69 BL69 BLB69 WL52 VDD VSS bitcell_6t
XC52_70 BL70 BLB70 WL52 VDD VSS bitcell_6t
XC52_71 BL71 BLB71 WL52 VDD VSS bitcell_6t
XC52_72 BL72 BLB72 WL52 VDD VSS bitcell_6t
XC52_73 BL73 BLB73 WL52 VDD VSS bitcell_6t
XC52_74 BL74 BLB74 WL52 VDD VSS bitcell_6t
XC52_75 BL75 BLB75 WL52 VDD VSS bitcell_6t
XC52_76 BL76 BLB76 WL52 VDD VSS bitcell_6t
XC52_77 BL77 BLB77 WL52 VDD VSS bitcell_6t
XC52_78 BL78 BLB78 WL52 VDD VSS bitcell_6t
XC52_79 BL79 BLB79 WL52 VDD VSS bitcell_6t
XC52_80 BL80 BLB80 WL52 VDD VSS bitcell_6t
XC52_81 BL81 BLB81 WL52 VDD VSS bitcell_6t
XC52_82 BL82 BLB82 WL52 VDD VSS bitcell_6t
XC52_83 BL83 BLB83 WL52 VDD VSS bitcell_6t
XC52_84 BL84 BLB84 WL52 VDD VSS bitcell_6t
XC52_85 BL85 BLB85 WL52 VDD VSS bitcell_6t
XC52_86 BL86 BLB86 WL52 VDD VSS bitcell_6t
XC52_87 BL87 BLB87 WL52 VDD VSS bitcell_6t
XC52_88 BL88 BLB88 WL52 VDD VSS bitcell_6t
XC52_89 BL89 BLB89 WL52 VDD VSS bitcell_6t
XC52_90 BL90 BLB90 WL52 VDD VSS bitcell_6t
XC52_91 BL91 BLB91 WL52 VDD VSS bitcell_6t
XC52_92 BL92 BLB92 WL52 VDD VSS bitcell_6t
XC52_93 BL93 BLB93 WL52 VDD VSS bitcell_6t
XC52_94 BL94 BLB94 WL52 VDD VSS bitcell_6t
XC52_95 BL95 BLB95 WL52 VDD VSS bitcell_6t
XC52_96 BL96 BLB96 WL52 VDD VSS bitcell_6t
XC52_97 BL97 BLB97 WL52 VDD VSS bitcell_6t
XC52_98 BL98 BLB98 WL52 VDD VSS bitcell_6t
XC52_99 BL99 BLB99 WL52 VDD VSS bitcell_6t
XC52_100 BL100 BLB100 WL52 VDD VSS bitcell_6t
XC52_101 BL101 BLB101 WL52 VDD VSS bitcell_6t
XC52_102 BL102 BLB102 WL52 VDD VSS bitcell_6t
XC52_103 BL103 BLB103 WL52 VDD VSS bitcell_6t
XC52_104 BL104 BLB104 WL52 VDD VSS bitcell_6t
XC52_105 BL105 BLB105 WL52 VDD VSS bitcell_6t
XC52_106 BL106 BLB106 WL52 VDD VSS bitcell_6t
XC52_107 BL107 BLB107 WL52 VDD VSS bitcell_6t
XC52_108 BL108 BLB108 WL52 VDD VSS bitcell_6t
XC52_109 BL109 BLB109 WL52 VDD VSS bitcell_6t
XC52_110 BL110 BLB110 WL52 VDD VSS bitcell_6t
XC52_111 BL111 BLB111 WL52 VDD VSS bitcell_6t
XC52_112 BL112 BLB112 WL52 VDD VSS bitcell_6t
XC52_113 BL113 BLB113 WL52 VDD VSS bitcell_6t
XC52_114 BL114 BLB114 WL52 VDD VSS bitcell_6t
XC52_115 BL115 BLB115 WL52 VDD VSS bitcell_6t
XC52_116 BL116 BLB116 WL52 VDD VSS bitcell_6t
XC52_117 BL117 BLB117 WL52 VDD VSS bitcell_6t
XC52_118 BL118 BLB118 WL52 VDD VSS bitcell_6t
XC52_119 BL119 BLB119 WL52 VDD VSS bitcell_6t
XC52_120 BL120 BLB120 WL52 VDD VSS bitcell_6t
XC52_121 BL121 BLB121 WL52 VDD VSS bitcell_6t
XC52_122 BL122 BLB122 WL52 VDD VSS bitcell_6t
XC52_123 BL123 BLB123 WL52 VDD VSS bitcell_6t
XC52_124 BL124 BLB124 WL52 VDD VSS bitcell_6t
XC52_125 BL125 BLB125 WL52 VDD VSS bitcell_6t
XC52_126 BL126 BLB126 WL52 VDD VSS bitcell_6t
XC52_127 BL127 BLB127 WL52 VDD VSS bitcell_6t
XC53_0 BL0 BLB0 WL53 VDD VSS bitcell_6t
XC53_1 BL1 BLB1 WL53 VDD VSS bitcell_6t
XC53_2 BL2 BLB2 WL53 VDD VSS bitcell_6t
XC53_3 BL3 BLB3 WL53 VDD VSS bitcell_6t
XC53_4 BL4 BLB4 WL53 VDD VSS bitcell_6t
XC53_5 BL5 BLB5 WL53 VDD VSS bitcell_6t
XC53_6 BL6 BLB6 WL53 VDD VSS bitcell_6t
XC53_7 BL7 BLB7 WL53 VDD VSS bitcell_6t
XC53_8 BL8 BLB8 WL53 VDD VSS bitcell_6t
XC53_9 BL9 BLB9 WL53 VDD VSS bitcell_6t
XC53_10 BL10 BLB10 WL53 VDD VSS bitcell_6t
XC53_11 BL11 BLB11 WL53 VDD VSS bitcell_6t
XC53_12 BL12 BLB12 WL53 VDD VSS bitcell_6t
XC53_13 BL13 BLB13 WL53 VDD VSS bitcell_6t
XC53_14 BL14 BLB14 WL53 VDD VSS bitcell_6t
XC53_15 BL15 BLB15 WL53 VDD VSS bitcell_6t
XC53_16 BL16 BLB16 WL53 VDD VSS bitcell_6t
XC53_17 BL17 BLB17 WL53 VDD VSS bitcell_6t
XC53_18 BL18 BLB18 WL53 VDD VSS bitcell_6t
XC53_19 BL19 BLB19 WL53 VDD VSS bitcell_6t
XC53_20 BL20 BLB20 WL53 VDD VSS bitcell_6t
XC53_21 BL21 BLB21 WL53 VDD VSS bitcell_6t
XC53_22 BL22 BLB22 WL53 VDD VSS bitcell_6t
XC53_23 BL23 BLB23 WL53 VDD VSS bitcell_6t
XC53_24 BL24 BLB24 WL53 VDD VSS bitcell_6t
XC53_25 BL25 BLB25 WL53 VDD VSS bitcell_6t
XC53_26 BL26 BLB26 WL53 VDD VSS bitcell_6t
XC53_27 BL27 BLB27 WL53 VDD VSS bitcell_6t
XC53_28 BL28 BLB28 WL53 VDD VSS bitcell_6t
XC53_29 BL29 BLB29 WL53 VDD VSS bitcell_6t
XC53_30 BL30 BLB30 WL53 VDD VSS bitcell_6t
XC53_31 BL31 BLB31 WL53 VDD VSS bitcell_6t
XC53_32 BL32 BLB32 WL53 VDD VSS bitcell_6t
XC53_33 BL33 BLB33 WL53 VDD VSS bitcell_6t
XC53_34 BL34 BLB34 WL53 VDD VSS bitcell_6t
XC53_35 BL35 BLB35 WL53 VDD VSS bitcell_6t
XC53_36 BL36 BLB36 WL53 VDD VSS bitcell_6t
XC53_37 BL37 BLB37 WL53 VDD VSS bitcell_6t
XC53_38 BL38 BLB38 WL53 VDD VSS bitcell_6t
XC53_39 BL39 BLB39 WL53 VDD VSS bitcell_6t
XC53_40 BL40 BLB40 WL53 VDD VSS bitcell_6t
XC53_41 BL41 BLB41 WL53 VDD VSS bitcell_6t
XC53_42 BL42 BLB42 WL53 VDD VSS bitcell_6t
XC53_43 BL43 BLB43 WL53 VDD VSS bitcell_6t
XC53_44 BL44 BLB44 WL53 VDD VSS bitcell_6t
XC53_45 BL45 BLB45 WL53 VDD VSS bitcell_6t
XC53_46 BL46 BLB46 WL53 VDD VSS bitcell_6t
XC53_47 BL47 BLB47 WL53 VDD VSS bitcell_6t
XC53_48 BL48 BLB48 WL53 VDD VSS bitcell_6t
XC53_49 BL49 BLB49 WL53 VDD VSS bitcell_6t
XC53_50 BL50 BLB50 WL53 VDD VSS bitcell_6t
XC53_51 BL51 BLB51 WL53 VDD VSS bitcell_6t
XC53_52 BL52 BLB52 WL53 VDD VSS bitcell_6t
XC53_53 BL53 BLB53 WL53 VDD VSS bitcell_6t
XC53_54 BL54 BLB54 WL53 VDD VSS bitcell_6t
XC53_55 BL55 BLB55 WL53 VDD VSS bitcell_6t
XC53_56 BL56 BLB56 WL53 VDD VSS bitcell_6t
XC53_57 BL57 BLB57 WL53 VDD VSS bitcell_6t
XC53_58 BL58 BLB58 WL53 VDD VSS bitcell_6t
XC53_59 BL59 BLB59 WL53 VDD VSS bitcell_6t
XC53_60 BL60 BLB60 WL53 VDD VSS bitcell_6t
XC53_61 BL61 BLB61 WL53 VDD VSS bitcell_6t
XC53_62 BL62 BLB62 WL53 VDD VSS bitcell_6t
XC53_63 BL63 BLB63 WL53 VDD VSS bitcell_6t
XC53_64 BL64 BLB64 WL53 VDD VSS bitcell_6t
XC53_65 BL65 BLB65 WL53 VDD VSS bitcell_6t
XC53_66 BL66 BLB66 WL53 VDD VSS bitcell_6t
XC53_67 BL67 BLB67 WL53 VDD VSS bitcell_6t
XC53_68 BL68 BLB68 WL53 VDD VSS bitcell_6t
XC53_69 BL69 BLB69 WL53 VDD VSS bitcell_6t
XC53_70 BL70 BLB70 WL53 VDD VSS bitcell_6t
XC53_71 BL71 BLB71 WL53 VDD VSS bitcell_6t
XC53_72 BL72 BLB72 WL53 VDD VSS bitcell_6t
XC53_73 BL73 BLB73 WL53 VDD VSS bitcell_6t
XC53_74 BL74 BLB74 WL53 VDD VSS bitcell_6t
XC53_75 BL75 BLB75 WL53 VDD VSS bitcell_6t
XC53_76 BL76 BLB76 WL53 VDD VSS bitcell_6t
XC53_77 BL77 BLB77 WL53 VDD VSS bitcell_6t
XC53_78 BL78 BLB78 WL53 VDD VSS bitcell_6t
XC53_79 BL79 BLB79 WL53 VDD VSS bitcell_6t
XC53_80 BL80 BLB80 WL53 VDD VSS bitcell_6t
XC53_81 BL81 BLB81 WL53 VDD VSS bitcell_6t
XC53_82 BL82 BLB82 WL53 VDD VSS bitcell_6t
XC53_83 BL83 BLB83 WL53 VDD VSS bitcell_6t
XC53_84 BL84 BLB84 WL53 VDD VSS bitcell_6t
XC53_85 BL85 BLB85 WL53 VDD VSS bitcell_6t
XC53_86 BL86 BLB86 WL53 VDD VSS bitcell_6t
XC53_87 BL87 BLB87 WL53 VDD VSS bitcell_6t
XC53_88 BL88 BLB88 WL53 VDD VSS bitcell_6t
XC53_89 BL89 BLB89 WL53 VDD VSS bitcell_6t
XC53_90 BL90 BLB90 WL53 VDD VSS bitcell_6t
XC53_91 BL91 BLB91 WL53 VDD VSS bitcell_6t
XC53_92 BL92 BLB92 WL53 VDD VSS bitcell_6t
XC53_93 BL93 BLB93 WL53 VDD VSS bitcell_6t
XC53_94 BL94 BLB94 WL53 VDD VSS bitcell_6t
XC53_95 BL95 BLB95 WL53 VDD VSS bitcell_6t
XC53_96 BL96 BLB96 WL53 VDD VSS bitcell_6t
XC53_97 BL97 BLB97 WL53 VDD VSS bitcell_6t
XC53_98 BL98 BLB98 WL53 VDD VSS bitcell_6t
XC53_99 BL99 BLB99 WL53 VDD VSS bitcell_6t
XC53_100 BL100 BLB100 WL53 VDD VSS bitcell_6t
XC53_101 BL101 BLB101 WL53 VDD VSS bitcell_6t
XC53_102 BL102 BLB102 WL53 VDD VSS bitcell_6t
XC53_103 BL103 BLB103 WL53 VDD VSS bitcell_6t
XC53_104 BL104 BLB104 WL53 VDD VSS bitcell_6t
XC53_105 BL105 BLB105 WL53 VDD VSS bitcell_6t
XC53_106 BL106 BLB106 WL53 VDD VSS bitcell_6t
XC53_107 BL107 BLB107 WL53 VDD VSS bitcell_6t
XC53_108 BL108 BLB108 WL53 VDD VSS bitcell_6t
XC53_109 BL109 BLB109 WL53 VDD VSS bitcell_6t
XC53_110 BL110 BLB110 WL53 VDD VSS bitcell_6t
XC53_111 BL111 BLB111 WL53 VDD VSS bitcell_6t
XC53_112 BL112 BLB112 WL53 VDD VSS bitcell_6t
XC53_113 BL113 BLB113 WL53 VDD VSS bitcell_6t
XC53_114 BL114 BLB114 WL53 VDD VSS bitcell_6t
XC53_115 BL115 BLB115 WL53 VDD VSS bitcell_6t
XC53_116 BL116 BLB116 WL53 VDD VSS bitcell_6t
XC53_117 BL117 BLB117 WL53 VDD VSS bitcell_6t
XC53_118 BL118 BLB118 WL53 VDD VSS bitcell_6t
XC53_119 BL119 BLB119 WL53 VDD VSS bitcell_6t
XC53_120 BL120 BLB120 WL53 VDD VSS bitcell_6t
XC53_121 BL121 BLB121 WL53 VDD VSS bitcell_6t
XC53_122 BL122 BLB122 WL53 VDD VSS bitcell_6t
XC53_123 BL123 BLB123 WL53 VDD VSS bitcell_6t
XC53_124 BL124 BLB124 WL53 VDD VSS bitcell_6t
XC53_125 BL125 BLB125 WL53 VDD VSS bitcell_6t
XC53_126 BL126 BLB126 WL53 VDD VSS bitcell_6t
XC53_127 BL127 BLB127 WL53 VDD VSS bitcell_6t
XC54_0 BL0 BLB0 WL54 VDD VSS bitcell_6t
XC54_1 BL1 BLB1 WL54 VDD VSS bitcell_6t
XC54_2 BL2 BLB2 WL54 VDD VSS bitcell_6t
XC54_3 BL3 BLB3 WL54 VDD VSS bitcell_6t
XC54_4 BL4 BLB4 WL54 VDD VSS bitcell_6t
XC54_5 BL5 BLB5 WL54 VDD VSS bitcell_6t
XC54_6 BL6 BLB6 WL54 VDD VSS bitcell_6t
XC54_7 BL7 BLB7 WL54 VDD VSS bitcell_6t
XC54_8 BL8 BLB8 WL54 VDD VSS bitcell_6t
XC54_9 BL9 BLB9 WL54 VDD VSS bitcell_6t
XC54_10 BL10 BLB10 WL54 VDD VSS bitcell_6t
XC54_11 BL11 BLB11 WL54 VDD VSS bitcell_6t
XC54_12 BL12 BLB12 WL54 VDD VSS bitcell_6t
XC54_13 BL13 BLB13 WL54 VDD VSS bitcell_6t
XC54_14 BL14 BLB14 WL54 VDD VSS bitcell_6t
XC54_15 BL15 BLB15 WL54 VDD VSS bitcell_6t
XC54_16 BL16 BLB16 WL54 VDD VSS bitcell_6t
XC54_17 BL17 BLB17 WL54 VDD VSS bitcell_6t
XC54_18 BL18 BLB18 WL54 VDD VSS bitcell_6t
XC54_19 BL19 BLB19 WL54 VDD VSS bitcell_6t
XC54_20 BL20 BLB20 WL54 VDD VSS bitcell_6t
XC54_21 BL21 BLB21 WL54 VDD VSS bitcell_6t
XC54_22 BL22 BLB22 WL54 VDD VSS bitcell_6t
XC54_23 BL23 BLB23 WL54 VDD VSS bitcell_6t
XC54_24 BL24 BLB24 WL54 VDD VSS bitcell_6t
XC54_25 BL25 BLB25 WL54 VDD VSS bitcell_6t
XC54_26 BL26 BLB26 WL54 VDD VSS bitcell_6t
XC54_27 BL27 BLB27 WL54 VDD VSS bitcell_6t
XC54_28 BL28 BLB28 WL54 VDD VSS bitcell_6t
XC54_29 BL29 BLB29 WL54 VDD VSS bitcell_6t
XC54_30 BL30 BLB30 WL54 VDD VSS bitcell_6t
XC54_31 BL31 BLB31 WL54 VDD VSS bitcell_6t
XC54_32 BL32 BLB32 WL54 VDD VSS bitcell_6t
XC54_33 BL33 BLB33 WL54 VDD VSS bitcell_6t
XC54_34 BL34 BLB34 WL54 VDD VSS bitcell_6t
XC54_35 BL35 BLB35 WL54 VDD VSS bitcell_6t
XC54_36 BL36 BLB36 WL54 VDD VSS bitcell_6t
XC54_37 BL37 BLB37 WL54 VDD VSS bitcell_6t
XC54_38 BL38 BLB38 WL54 VDD VSS bitcell_6t
XC54_39 BL39 BLB39 WL54 VDD VSS bitcell_6t
XC54_40 BL40 BLB40 WL54 VDD VSS bitcell_6t
XC54_41 BL41 BLB41 WL54 VDD VSS bitcell_6t
XC54_42 BL42 BLB42 WL54 VDD VSS bitcell_6t
XC54_43 BL43 BLB43 WL54 VDD VSS bitcell_6t
XC54_44 BL44 BLB44 WL54 VDD VSS bitcell_6t
XC54_45 BL45 BLB45 WL54 VDD VSS bitcell_6t
XC54_46 BL46 BLB46 WL54 VDD VSS bitcell_6t
XC54_47 BL47 BLB47 WL54 VDD VSS bitcell_6t
XC54_48 BL48 BLB48 WL54 VDD VSS bitcell_6t
XC54_49 BL49 BLB49 WL54 VDD VSS bitcell_6t
XC54_50 BL50 BLB50 WL54 VDD VSS bitcell_6t
XC54_51 BL51 BLB51 WL54 VDD VSS bitcell_6t
XC54_52 BL52 BLB52 WL54 VDD VSS bitcell_6t
XC54_53 BL53 BLB53 WL54 VDD VSS bitcell_6t
XC54_54 BL54 BLB54 WL54 VDD VSS bitcell_6t
XC54_55 BL55 BLB55 WL54 VDD VSS bitcell_6t
XC54_56 BL56 BLB56 WL54 VDD VSS bitcell_6t
XC54_57 BL57 BLB57 WL54 VDD VSS bitcell_6t
XC54_58 BL58 BLB58 WL54 VDD VSS bitcell_6t
XC54_59 BL59 BLB59 WL54 VDD VSS bitcell_6t
XC54_60 BL60 BLB60 WL54 VDD VSS bitcell_6t
XC54_61 BL61 BLB61 WL54 VDD VSS bitcell_6t
XC54_62 BL62 BLB62 WL54 VDD VSS bitcell_6t
XC54_63 BL63 BLB63 WL54 VDD VSS bitcell_6t
XC54_64 BL64 BLB64 WL54 VDD VSS bitcell_6t
XC54_65 BL65 BLB65 WL54 VDD VSS bitcell_6t
XC54_66 BL66 BLB66 WL54 VDD VSS bitcell_6t
XC54_67 BL67 BLB67 WL54 VDD VSS bitcell_6t
XC54_68 BL68 BLB68 WL54 VDD VSS bitcell_6t
XC54_69 BL69 BLB69 WL54 VDD VSS bitcell_6t
XC54_70 BL70 BLB70 WL54 VDD VSS bitcell_6t
XC54_71 BL71 BLB71 WL54 VDD VSS bitcell_6t
XC54_72 BL72 BLB72 WL54 VDD VSS bitcell_6t
XC54_73 BL73 BLB73 WL54 VDD VSS bitcell_6t
XC54_74 BL74 BLB74 WL54 VDD VSS bitcell_6t
XC54_75 BL75 BLB75 WL54 VDD VSS bitcell_6t
XC54_76 BL76 BLB76 WL54 VDD VSS bitcell_6t
XC54_77 BL77 BLB77 WL54 VDD VSS bitcell_6t
XC54_78 BL78 BLB78 WL54 VDD VSS bitcell_6t
XC54_79 BL79 BLB79 WL54 VDD VSS bitcell_6t
XC54_80 BL80 BLB80 WL54 VDD VSS bitcell_6t
XC54_81 BL81 BLB81 WL54 VDD VSS bitcell_6t
XC54_82 BL82 BLB82 WL54 VDD VSS bitcell_6t
XC54_83 BL83 BLB83 WL54 VDD VSS bitcell_6t
XC54_84 BL84 BLB84 WL54 VDD VSS bitcell_6t
XC54_85 BL85 BLB85 WL54 VDD VSS bitcell_6t
XC54_86 BL86 BLB86 WL54 VDD VSS bitcell_6t
XC54_87 BL87 BLB87 WL54 VDD VSS bitcell_6t
XC54_88 BL88 BLB88 WL54 VDD VSS bitcell_6t
XC54_89 BL89 BLB89 WL54 VDD VSS bitcell_6t
XC54_90 BL90 BLB90 WL54 VDD VSS bitcell_6t
XC54_91 BL91 BLB91 WL54 VDD VSS bitcell_6t
XC54_92 BL92 BLB92 WL54 VDD VSS bitcell_6t
XC54_93 BL93 BLB93 WL54 VDD VSS bitcell_6t
XC54_94 BL94 BLB94 WL54 VDD VSS bitcell_6t
XC54_95 BL95 BLB95 WL54 VDD VSS bitcell_6t
XC54_96 BL96 BLB96 WL54 VDD VSS bitcell_6t
XC54_97 BL97 BLB97 WL54 VDD VSS bitcell_6t
XC54_98 BL98 BLB98 WL54 VDD VSS bitcell_6t
XC54_99 BL99 BLB99 WL54 VDD VSS bitcell_6t
XC54_100 BL100 BLB100 WL54 VDD VSS bitcell_6t
XC54_101 BL101 BLB101 WL54 VDD VSS bitcell_6t
XC54_102 BL102 BLB102 WL54 VDD VSS bitcell_6t
XC54_103 BL103 BLB103 WL54 VDD VSS bitcell_6t
XC54_104 BL104 BLB104 WL54 VDD VSS bitcell_6t
XC54_105 BL105 BLB105 WL54 VDD VSS bitcell_6t
XC54_106 BL106 BLB106 WL54 VDD VSS bitcell_6t
XC54_107 BL107 BLB107 WL54 VDD VSS bitcell_6t
XC54_108 BL108 BLB108 WL54 VDD VSS bitcell_6t
XC54_109 BL109 BLB109 WL54 VDD VSS bitcell_6t
XC54_110 BL110 BLB110 WL54 VDD VSS bitcell_6t
XC54_111 BL111 BLB111 WL54 VDD VSS bitcell_6t
XC54_112 BL112 BLB112 WL54 VDD VSS bitcell_6t
XC54_113 BL113 BLB113 WL54 VDD VSS bitcell_6t
XC54_114 BL114 BLB114 WL54 VDD VSS bitcell_6t
XC54_115 BL115 BLB115 WL54 VDD VSS bitcell_6t
XC54_116 BL116 BLB116 WL54 VDD VSS bitcell_6t
XC54_117 BL117 BLB117 WL54 VDD VSS bitcell_6t
XC54_118 BL118 BLB118 WL54 VDD VSS bitcell_6t
XC54_119 BL119 BLB119 WL54 VDD VSS bitcell_6t
XC54_120 BL120 BLB120 WL54 VDD VSS bitcell_6t
XC54_121 BL121 BLB121 WL54 VDD VSS bitcell_6t
XC54_122 BL122 BLB122 WL54 VDD VSS bitcell_6t
XC54_123 BL123 BLB123 WL54 VDD VSS bitcell_6t
XC54_124 BL124 BLB124 WL54 VDD VSS bitcell_6t
XC54_125 BL125 BLB125 WL54 VDD VSS bitcell_6t
XC54_126 BL126 BLB126 WL54 VDD VSS bitcell_6t
XC54_127 BL127 BLB127 WL54 VDD VSS bitcell_6t
XC55_0 BL0 BLB0 WL55 VDD VSS bitcell_6t
XC55_1 BL1 BLB1 WL55 VDD VSS bitcell_6t
XC55_2 BL2 BLB2 WL55 VDD VSS bitcell_6t
XC55_3 BL3 BLB3 WL55 VDD VSS bitcell_6t
XC55_4 BL4 BLB4 WL55 VDD VSS bitcell_6t
XC55_5 BL5 BLB5 WL55 VDD VSS bitcell_6t
XC55_6 BL6 BLB6 WL55 VDD VSS bitcell_6t
XC55_7 BL7 BLB7 WL55 VDD VSS bitcell_6t
XC55_8 BL8 BLB8 WL55 VDD VSS bitcell_6t
XC55_9 BL9 BLB9 WL55 VDD VSS bitcell_6t
XC55_10 BL10 BLB10 WL55 VDD VSS bitcell_6t
XC55_11 BL11 BLB11 WL55 VDD VSS bitcell_6t
XC55_12 BL12 BLB12 WL55 VDD VSS bitcell_6t
XC55_13 BL13 BLB13 WL55 VDD VSS bitcell_6t
XC55_14 BL14 BLB14 WL55 VDD VSS bitcell_6t
XC55_15 BL15 BLB15 WL55 VDD VSS bitcell_6t
XC55_16 BL16 BLB16 WL55 VDD VSS bitcell_6t
XC55_17 BL17 BLB17 WL55 VDD VSS bitcell_6t
XC55_18 BL18 BLB18 WL55 VDD VSS bitcell_6t
XC55_19 BL19 BLB19 WL55 VDD VSS bitcell_6t
XC55_20 BL20 BLB20 WL55 VDD VSS bitcell_6t
XC55_21 BL21 BLB21 WL55 VDD VSS bitcell_6t
XC55_22 BL22 BLB22 WL55 VDD VSS bitcell_6t
XC55_23 BL23 BLB23 WL55 VDD VSS bitcell_6t
XC55_24 BL24 BLB24 WL55 VDD VSS bitcell_6t
XC55_25 BL25 BLB25 WL55 VDD VSS bitcell_6t
XC55_26 BL26 BLB26 WL55 VDD VSS bitcell_6t
XC55_27 BL27 BLB27 WL55 VDD VSS bitcell_6t
XC55_28 BL28 BLB28 WL55 VDD VSS bitcell_6t
XC55_29 BL29 BLB29 WL55 VDD VSS bitcell_6t
XC55_30 BL30 BLB30 WL55 VDD VSS bitcell_6t
XC55_31 BL31 BLB31 WL55 VDD VSS bitcell_6t
XC55_32 BL32 BLB32 WL55 VDD VSS bitcell_6t
XC55_33 BL33 BLB33 WL55 VDD VSS bitcell_6t
XC55_34 BL34 BLB34 WL55 VDD VSS bitcell_6t
XC55_35 BL35 BLB35 WL55 VDD VSS bitcell_6t
XC55_36 BL36 BLB36 WL55 VDD VSS bitcell_6t
XC55_37 BL37 BLB37 WL55 VDD VSS bitcell_6t
XC55_38 BL38 BLB38 WL55 VDD VSS bitcell_6t
XC55_39 BL39 BLB39 WL55 VDD VSS bitcell_6t
XC55_40 BL40 BLB40 WL55 VDD VSS bitcell_6t
XC55_41 BL41 BLB41 WL55 VDD VSS bitcell_6t
XC55_42 BL42 BLB42 WL55 VDD VSS bitcell_6t
XC55_43 BL43 BLB43 WL55 VDD VSS bitcell_6t
XC55_44 BL44 BLB44 WL55 VDD VSS bitcell_6t
XC55_45 BL45 BLB45 WL55 VDD VSS bitcell_6t
XC55_46 BL46 BLB46 WL55 VDD VSS bitcell_6t
XC55_47 BL47 BLB47 WL55 VDD VSS bitcell_6t
XC55_48 BL48 BLB48 WL55 VDD VSS bitcell_6t
XC55_49 BL49 BLB49 WL55 VDD VSS bitcell_6t
XC55_50 BL50 BLB50 WL55 VDD VSS bitcell_6t
XC55_51 BL51 BLB51 WL55 VDD VSS bitcell_6t
XC55_52 BL52 BLB52 WL55 VDD VSS bitcell_6t
XC55_53 BL53 BLB53 WL55 VDD VSS bitcell_6t
XC55_54 BL54 BLB54 WL55 VDD VSS bitcell_6t
XC55_55 BL55 BLB55 WL55 VDD VSS bitcell_6t
XC55_56 BL56 BLB56 WL55 VDD VSS bitcell_6t
XC55_57 BL57 BLB57 WL55 VDD VSS bitcell_6t
XC55_58 BL58 BLB58 WL55 VDD VSS bitcell_6t
XC55_59 BL59 BLB59 WL55 VDD VSS bitcell_6t
XC55_60 BL60 BLB60 WL55 VDD VSS bitcell_6t
XC55_61 BL61 BLB61 WL55 VDD VSS bitcell_6t
XC55_62 BL62 BLB62 WL55 VDD VSS bitcell_6t
XC55_63 BL63 BLB63 WL55 VDD VSS bitcell_6t
XC55_64 BL64 BLB64 WL55 VDD VSS bitcell_6t
XC55_65 BL65 BLB65 WL55 VDD VSS bitcell_6t
XC55_66 BL66 BLB66 WL55 VDD VSS bitcell_6t
XC55_67 BL67 BLB67 WL55 VDD VSS bitcell_6t
XC55_68 BL68 BLB68 WL55 VDD VSS bitcell_6t
XC55_69 BL69 BLB69 WL55 VDD VSS bitcell_6t
XC55_70 BL70 BLB70 WL55 VDD VSS bitcell_6t
XC55_71 BL71 BLB71 WL55 VDD VSS bitcell_6t
XC55_72 BL72 BLB72 WL55 VDD VSS bitcell_6t
XC55_73 BL73 BLB73 WL55 VDD VSS bitcell_6t
XC55_74 BL74 BLB74 WL55 VDD VSS bitcell_6t
XC55_75 BL75 BLB75 WL55 VDD VSS bitcell_6t
XC55_76 BL76 BLB76 WL55 VDD VSS bitcell_6t
XC55_77 BL77 BLB77 WL55 VDD VSS bitcell_6t
XC55_78 BL78 BLB78 WL55 VDD VSS bitcell_6t
XC55_79 BL79 BLB79 WL55 VDD VSS bitcell_6t
XC55_80 BL80 BLB80 WL55 VDD VSS bitcell_6t
XC55_81 BL81 BLB81 WL55 VDD VSS bitcell_6t
XC55_82 BL82 BLB82 WL55 VDD VSS bitcell_6t
XC55_83 BL83 BLB83 WL55 VDD VSS bitcell_6t
XC55_84 BL84 BLB84 WL55 VDD VSS bitcell_6t
XC55_85 BL85 BLB85 WL55 VDD VSS bitcell_6t
XC55_86 BL86 BLB86 WL55 VDD VSS bitcell_6t
XC55_87 BL87 BLB87 WL55 VDD VSS bitcell_6t
XC55_88 BL88 BLB88 WL55 VDD VSS bitcell_6t
XC55_89 BL89 BLB89 WL55 VDD VSS bitcell_6t
XC55_90 BL90 BLB90 WL55 VDD VSS bitcell_6t
XC55_91 BL91 BLB91 WL55 VDD VSS bitcell_6t
XC55_92 BL92 BLB92 WL55 VDD VSS bitcell_6t
XC55_93 BL93 BLB93 WL55 VDD VSS bitcell_6t
XC55_94 BL94 BLB94 WL55 VDD VSS bitcell_6t
XC55_95 BL95 BLB95 WL55 VDD VSS bitcell_6t
XC55_96 BL96 BLB96 WL55 VDD VSS bitcell_6t
XC55_97 BL97 BLB97 WL55 VDD VSS bitcell_6t
XC55_98 BL98 BLB98 WL55 VDD VSS bitcell_6t
XC55_99 BL99 BLB99 WL55 VDD VSS bitcell_6t
XC55_100 BL100 BLB100 WL55 VDD VSS bitcell_6t
XC55_101 BL101 BLB101 WL55 VDD VSS bitcell_6t
XC55_102 BL102 BLB102 WL55 VDD VSS bitcell_6t
XC55_103 BL103 BLB103 WL55 VDD VSS bitcell_6t
XC55_104 BL104 BLB104 WL55 VDD VSS bitcell_6t
XC55_105 BL105 BLB105 WL55 VDD VSS bitcell_6t
XC55_106 BL106 BLB106 WL55 VDD VSS bitcell_6t
XC55_107 BL107 BLB107 WL55 VDD VSS bitcell_6t
XC55_108 BL108 BLB108 WL55 VDD VSS bitcell_6t
XC55_109 BL109 BLB109 WL55 VDD VSS bitcell_6t
XC55_110 BL110 BLB110 WL55 VDD VSS bitcell_6t
XC55_111 BL111 BLB111 WL55 VDD VSS bitcell_6t
XC55_112 BL112 BLB112 WL55 VDD VSS bitcell_6t
XC55_113 BL113 BLB113 WL55 VDD VSS bitcell_6t
XC55_114 BL114 BLB114 WL55 VDD VSS bitcell_6t
XC55_115 BL115 BLB115 WL55 VDD VSS bitcell_6t
XC55_116 BL116 BLB116 WL55 VDD VSS bitcell_6t
XC55_117 BL117 BLB117 WL55 VDD VSS bitcell_6t
XC55_118 BL118 BLB118 WL55 VDD VSS bitcell_6t
XC55_119 BL119 BLB119 WL55 VDD VSS bitcell_6t
XC55_120 BL120 BLB120 WL55 VDD VSS bitcell_6t
XC55_121 BL121 BLB121 WL55 VDD VSS bitcell_6t
XC55_122 BL122 BLB122 WL55 VDD VSS bitcell_6t
XC55_123 BL123 BLB123 WL55 VDD VSS bitcell_6t
XC55_124 BL124 BLB124 WL55 VDD VSS bitcell_6t
XC55_125 BL125 BLB125 WL55 VDD VSS bitcell_6t
XC55_126 BL126 BLB126 WL55 VDD VSS bitcell_6t
XC55_127 BL127 BLB127 WL55 VDD VSS bitcell_6t
XC56_0 BL0 BLB0 WL56 VDD VSS bitcell_6t
XC56_1 BL1 BLB1 WL56 VDD VSS bitcell_6t
XC56_2 BL2 BLB2 WL56 VDD VSS bitcell_6t
XC56_3 BL3 BLB3 WL56 VDD VSS bitcell_6t
XC56_4 BL4 BLB4 WL56 VDD VSS bitcell_6t
XC56_5 BL5 BLB5 WL56 VDD VSS bitcell_6t
XC56_6 BL6 BLB6 WL56 VDD VSS bitcell_6t
XC56_7 BL7 BLB7 WL56 VDD VSS bitcell_6t
XC56_8 BL8 BLB8 WL56 VDD VSS bitcell_6t
XC56_9 BL9 BLB9 WL56 VDD VSS bitcell_6t
XC56_10 BL10 BLB10 WL56 VDD VSS bitcell_6t
XC56_11 BL11 BLB11 WL56 VDD VSS bitcell_6t
XC56_12 BL12 BLB12 WL56 VDD VSS bitcell_6t
XC56_13 BL13 BLB13 WL56 VDD VSS bitcell_6t
XC56_14 BL14 BLB14 WL56 VDD VSS bitcell_6t
XC56_15 BL15 BLB15 WL56 VDD VSS bitcell_6t
XC56_16 BL16 BLB16 WL56 VDD VSS bitcell_6t
XC56_17 BL17 BLB17 WL56 VDD VSS bitcell_6t
XC56_18 BL18 BLB18 WL56 VDD VSS bitcell_6t
XC56_19 BL19 BLB19 WL56 VDD VSS bitcell_6t
XC56_20 BL20 BLB20 WL56 VDD VSS bitcell_6t
XC56_21 BL21 BLB21 WL56 VDD VSS bitcell_6t
XC56_22 BL22 BLB22 WL56 VDD VSS bitcell_6t
XC56_23 BL23 BLB23 WL56 VDD VSS bitcell_6t
XC56_24 BL24 BLB24 WL56 VDD VSS bitcell_6t
XC56_25 BL25 BLB25 WL56 VDD VSS bitcell_6t
XC56_26 BL26 BLB26 WL56 VDD VSS bitcell_6t
XC56_27 BL27 BLB27 WL56 VDD VSS bitcell_6t
XC56_28 BL28 BLB28 WL56 VDD VSS bitcell_6t
XC56_29 BL29 BLB29 WL56 VDD VSS bitcell_6t
XC56_30 BL30 BLB30 WL56 VDD VSS bitcell_6t
XC56_31 BL31 BLB31 WL56 VDD VSS bitcell_6t
XC56_32 BL32 BLB32 WL56 VDD VSS bitcell_6t
XC56_33 BL33 BLB33 WL56 VDD VSS bitcell_6t
XC56_34 BL34 BLB34 WL56 VDD VSS bitcell_6t
XC56_35 BL35 BLB35 WL56 VDD VSS bitcell_6t
XC56_36 BL36 BLB36 WL56 VDD VSS bitcell_6t
XC56_37 BL37 BLB37 WL56 VDD VSS bitcell_6t
XC56_38 BL38 BLB38 WL56 VDD VSS bitcell_6t
XC56_39 BL39 BLB39 WL56 VDD VSS bitcell_6t
XC56_40 BL40 BLB40 WL56 VDD VSS bitcell_6t
XC56_41 BL41 BLB41 WL56 VDD VSS bitcell_6t
XC56_42 BL42 BLB42 WL56 VDD VSS bitcell_6t
XC56_43 BL43 BLB43 WL56 VDD VSS bitcell_6t
XC56_44 BL44 BLB44 WL56 VDD VSS bitcell_6t
XC56_45 BL45 BLB45 WL56 VDD VSS bitcell_6t
XC56_46 BL46 BLB46 WL56 VDD VSS bitcell_6t
XC56_47 BL47 BLB47 WL56 VDD VSS bitcell_6t
XC56_48 BL48 BLB48 WL56 VDD VSS bitcell_6t
XC56_49 BL49 BLB49 WL56 VDD VSS bitcell_6t
XC56_50 BL50 BLB50 WL56 VDD VSS bitcell_6t
XC56_51 BL51 BLB51 WL56 VDD VSS bitcell_6t
XC56_52 BL52 BLB52 WL56 VDD VSS bitcell_6t
XC56_53 BL53 BLB53 WL56 VDD VSS bitcell_6t
XC56_54 BL54 BLB54 WL56 VDD VSS bitcell_6t
XC56_55 BL55 BLB55 WL56 VDD VSS bitcell_6t
XC56_56 BL56 BLB56 WL56 VDD VSS bitcell_6t
XC56_57 BL57 BLB57 WL56 VDD VSS bitcell_6t
XC56_58 BL58 BLB58 WL56 VDD VSS bitcell_6t
XC56_59 BL59 BLB59 WL56 VDD VSS bitcell_6t
XC56_60 BL60 BLB60 WL56 VDD VSS bitcell_6t
XC56_61 BL61 BLB61 WL56 VDD VSS bitcell_6t
XC56_62 BL62 BLB62 WL56 VDD VSS bitcell_6t
XC56_63 BL63 BLB63 WL56 VDD VSS bitcell_6t
XC56_64 BL64 BLB64 WL56 VDD VSS bitcell_6t
XC56_65 BL65 BLB65 WL56 VDD VSS bitcell_6t
XC56_66 BL66 BLB66 WL56 VDD VSS bitcell_6t
XC56_67 BL67 BLB67 WL56 VDD VSS bitcell_6t
XC56_68 BL68 BLB68 WL56 VDD VSS bitcell_6t
XC56_69 BL69 BLB69 WL56 VDD VSS bitcell_6t
XC56_70 BL70 BLB70 WL56 VDD VSS bitcell_6t
XC56_71 BL71 BLB71 WL56 VDD VSS bitcell_6t
XC56_72 BL72 BLB72 WL56 VDD VSS bitcell_6t
XC56_73 BL73 BLB73 WL56 VDD VSS bitcell_6t
XC56_74 BL74 BLB74 WL56 VDD VSS bitcell_6t
XC56_75 BL75 BLB75 WL56 VDD VSS bitcell_6t
XC56_76 BL76 BLB76 WL56 VDD VSS bitcell_6t
XC56_77 BL77 BLB77 WL56 VDD VSS bitcell_6t
XC56_78 BL78 BLB78 WL56 VDD VSS bitcell_6t
XC56_79 BL79 BLB79 WL56 VDD VSS bitcell_6t
XC56_80 BL80 BLB80 WL56 VDD VSS bitcell_6t
XC56_81 BL81 BLB81 WL56 VDD VSS bitcell_6t
XC56_82 BL82 BLB82 WL56 VDD VSS bitcell_6t
XC56_83 BL83 BLB83 WL56 VDD VSS bitcell_6t
XC56_84 BL84 BLB84 WL56 VDD VSS bitcell_6t
XC56_85 BL85 BLB85 WL56 VDD VSS bitcell_6t
XC56_86 BL86 BLB86 WL56 VDD VSS bitcell_6t
XC56_87 BL87 BLB87 WL56 VDD VSS bitcell_6t
XC56_88 BL88 BLB88 WL56 VDD VSS bitcell_6t
XC56_89 BL89 BLB89 WL56 VDD VSS bitcell_6t
XC56_90 BL90 BLB90 WL56 VDD VSS bitcell_6t
XC56_91 BL91 BLB91 WL56 VDD VSS bitcell_6t
XC56_92 BL92 BLB92 WL56 VDD VSS bitcell_6t
XC56_93 BL93 BLB93 WL56 VDD VSS bitcell_6t
XC56_94 BL94 BLB94 WL56 VDD VSS bitcell_6t
XC56_95 BL95 BLB95 WL56 VDD VSS bitcell_6t
XC56_96 BL96 BLB96 WL56 VDD VSS bitcell_6t
XC56_97 BL97 BLB97 WL56 VDD VSS bitcell_6t
XC56_98 BL98 BLB98 WL56 VDD VSS bitcell_6t
XC56_99 BL99 BLB99 WL56 VDD VSS bitcell_6t
XC56_100 BL100 BLB100 WL56 VDD VSS bitcell_6t
XC56_101 BL101 BLB101 WL56 VDD VSS bitcell_6t
XC56_102 BL102 BLB102 WL56 VDD VSS bitcell_6t
XC56_103 BL103 BLB103 WL56 VDD VSS bitcell_6t
XC56_104 BL104 BLB104 WL56 VDD VSS bitcell_6t
XC56_105 BL105 BLB105 WL56 VDD VSS bitcell_6t
XC56_106 BL106 BLB106 WL56 VDD VSS bitcell_6t
XC56_107 BL107 BLB107 WL56 VDD VSS bitcell_6t
XC56_108 BL108 BLB108 WL56 VDD VSS bitcell_6t
XC56_109 BL109 BLB109 WL56 VDD VSS bitcell_6t
XC56_110 BL110 BLB110 WL56 VDD VSS bitcell_6t
XC56_111 BL111 BLB111 WL56 VDD VSS bitcell_6t
XC56_112 BL112 BLB112 WL56 VDD VSS bitcell_6t
XC56_113 BL113 BLB113 WL56 VDD VSS bitcell_6t
XC56_114 BL114 BLB114 WL56 VDD VSS bitcell_6t
XC56_115 BL115 BLB115 WL56 VDD VSS bitcell_6t
XC56_116 BL116 BLB116 WL56 VDD VSS bitcell_6t
XC56_117 BL117 BLB117 WL56 VDD VSS bitcell_6t
XC56_118 BL118 BLB118 WL56 VDD VSS bitcell_6t
XC56_119 BL119 BLB119 WL56 VDD VSS bitcell_6t
XC56_120 BL120 BLB120 WL56 VDD VSS bitcell_6t
XC56_121 BL121 BLB121 WL56 VDD VSS bitcell_6t
XC56_122 BL122 BLB122 WL56 VDD VSS bitcell_6t
XC56_123 BL123 BLB123 WL56 VDD VSS bitcell_6t
XC56_124 BL124 BLB124 WL56 VDD VSS bitcell_6t
XC56_125 BL125 BLB125 WL56 VDD VSS bitcell_6t
XC56_126 BL126 BLB126 WL56 VDD VSS bitcell_6t
XC56_127 BL127 BLB127 WL56 VDD VSS bitcell_6t
XC57_0 BL0 BLB0 WL57 VDD VSS bitcell_6t
XC57_1 BL1 BLB1 WL57 VDD VSS bitcell_6t
XC57_2 BL2 BLB2 WL57 VDD VSS bitcell_6t
XC57_3 BL3 BLB3 WL57 VDD VSS bitcell_6t
XC57_4 BL4 BLB4 WL57 VDD VSS bitcell_6t
XC57_5 BL5 BLB5 WL57 VDD VSS bitcell_6t
XC57_6 BL6 BLB6 WL57 VDD VSS bitcell_6t
XC57_7 BL7 BLB7 WL57 VDD VSS bitcell_6t
XC57_8 BL8 BLB8 WL57 VDD VSS bitcell_6t
XC57_9 BL9 BLB9 WL57 VDD VSS bitcell_6t
XC57_10 BL10 BLB10 WL57 VDD VSS bitcell_6t
XC57_11 BL11 BLB11 WL57 VDD VSS bitcell_6t
XC57_12 BL12 BLB12 WL57 VDD VSS bitcell_6t
XC57_13 BL13 BLB13 WL57 VDD VSS bitcell_6t
XC57_14 BL14 BLB14 WL57 VDD VSS bitcell_6t
XC57_15 BL15 BLB15 WL57 VDD VSS bitcell_6t
XC57_16 BL16 BLB16 WL57 VDD VSS bitcell_6t
XC57_17 BL17 BLB17 WL57 VDD VSS bitcell_6t
XC57_18 BL18 BLB18 WL57 VDD VSS bitcell_6t
XC57_19 BL19 BLB19 WL57 VDD VSS bitcell_6t
XC57_20 BL20 BLB20 WL57 VDD VSS bitcell_6t
XC57_21 BL21 BLB21 WL57 VDD VSS bitcell_6t
XC57_22 BL22 BLB22 WL57 VDD VSS bitcell_6t
XC57_23 BL23 BLB23 WL57 VDD VSS bitcell_6t
XC57_24 BL24 BLB24 WL57 VDD VSS bitcell_6t
XC57_25 BL25 BLB25 WL57 VDD VSS bitcell_6t
XC57_26 BL26 BLB26 WL57 VDD VSS bitcell_6t
XC57_27 BL27 BLB27 WL57 VDD VSS bitcell_6t
XC57_28 BL28 BLB28 WL57 VDD VSS bitcell_6t
XC57_29 BL29 BLB29 WL57 VDD VSS bitcell_6t
XC57_30 BL30 BLB30 WL57 VDD VSS bitcell_6t
XC57_31 BL31 BLB31 WL57 VDD VSS bitcell_6t
XC57_32 BL32 BLB32 WL57 VDD VSS bitcell_6t
XC57_33 BL33 BLB33 WL57 VDD VSS bitcell_6t
XC57_34 BL34 BLB34 WL57 VDD VSS bitcell_6t
XC57_35 BL35 BLB35 WL57 VDD VSS bitcell_6t
XC57_36 BL36 BLB36 WL57 VDD VSS bitcell_6t
XC57_37 BL37 BLB37 WL57 VDD VSS bitcell_6t
XC57_38 BL38 BLB38 WL57 VDD VSS bitcell_6t
XC57_39 BL39 BLB39 WL57 VDD VSS bitcell_6t
XC57_40 BL40 BLB40 WL57 VDD VSS bitcell_6t
XC57_41 BL41 BLB41 WL57 VDD VSS bitcell_6t
XC57_42 BL42 BLB42 WL57 VDD VSS bitcell_6t
XC57_43 BL43 BLB43 WL57 VDD VSS bitcell_6t
XC57_44 BL44 BLB44 WL57 VDD VSS bitcell_6t
XC57_45 BL45 BLB45 WL57 VDD VSS bitcell_6t
XC57_46 BL46 BLB46 WL57 VDD VSS bitcell_6t
XC57_47 BL47 BLB47 WL57 VDD VSS bitcell_6t
XC57_48 BL48 BLB48 WL57 VDD VSS bitcell_6t
XC57_49 BL49 BLB49 WL57 VDD VSS bitcell_6t
XC57_50 BL50 BLB50 WL57 VDD VSS bitcell_6t
XC57_51 BL51 BLB51 WL57 VDD VSS bitcell_6t
XC57_52 BL52 BLB52 WL57 VDD VSS bitcell_6t
XC57_53 BL53 BLB53 WL57 VDD VSS bitcell_6t
XC57_54 BL54 BLB54 WL57 VDD VSS bitcell_6t
XC57_55 BL55 BLB55 WL57 VDD VSS bitcell_6t
XC57_56 BL56 BLB56 WL57 VDD VSS bitcell_6t
XC57_57 BL57 BLB57 WL57 VDD VSS bitcell_6t
XC57_58 BL58 BLB58 WL57 VDD VSS bitcell_6t
XC57_59 BL59 BLB59 WL57 VDD VSS bitcell_6t
XC57_60 BL60 BLB60 WL57 VDD VSS bitcell_6t
XC57_61 BL61 BLB61 WL57 VDD VSS bitcell_6t
XC57_62 BL62 BLB62 WL57 VDD VSS bitcell_6t
XC57_63 BL63 BLB63 WL57 VDD VSS bitcell_6t
XC57_64 BL64 BLB64 WL57 VDD VSS bitcell_6t
XC57_65 BL65 BLB65 WL57 VDD VSS bitcell_6t
XC57_66 BL66 BLB66 WL57 VDD VSS bitcell_6t
XC57_67 BL67 BLB67 WL57 VDD VSS bitcell_6t
XC57_68 BL68 BLB68 WL57 VDD VSS bitcell_6t
XC57_69 BL69 BLB69 WL57 VDD VSS bitcell_6t
XC57_70 BL70 BLB70 WL57 VDD VSS bitcell_6t
XC57_71 BL71 BLB71 WL57 VDD VSS bitcell_6t
XC57_72 BL72 BLB72 WL57 VDD VSS bitcell_6t
XC57_73 BL73 BLB73 WL57 VDD VSS bitcell_6t
XC57_74 BL74 BLB74 WL57 VDD VSS bitcell_6t
XC57_75 BL75 BLB75 WL57 VDD VSS bitcell_6t
XC57_76 BL76 BLB76 WL57 VDD VSS bitcell_6t
XC57_77 BL77 BLB77 WL57 VDD VSS bitcell_6t
XC57_78 BL78 BLB78 WL57 VDD VSS bitcell_6t
XC57_79 BL79 BLB79 WL57 VDD VSS bitcell_6t
XC57_80 BL80 BLB80 WL57 VDD VSS bitcell_6t
XC57_81 BL81 BLB81 WL57 VDD VSS bitcell_6t
XC57_82 BL82 BLB82 WL57 VDD VSS bitcell_6t
XC57_83 BL83 BLB83 WL57 VDD VSS bitcell_6t
XC57_84 BL84 BLB84 WL57 VDD VSS bitcell_6t
XC57_85 BL85 BLB85 WL57 VDD VSS bitcell_6t
XC57_86 BL86 BLB86 WL57 VDD VSS bitcell_6t
XC57_87 BL87 BLB87 WL57 VDD VSS bitcell_6t
XC57_88 BL88 BLB88 WL57 VDD VSS bitcell_6t
XC57_89 BL89 BLB89 WL57 VDD VSS bitcell_6t
XC57_90 BL90 BLB90 WL57 VDD VSS bitcell_6t
XC57_91 BL91 BLB91 WL57 VDD VSS bitcell_6t
XC57_92 BL92 BLB92 WL57 VDD VSS bitcell_6t
XC57_93 BL93 BLB93 WL57 VDD VSS bitcell_6t
XC57_94 BL94 BLB94 WL57 VDD VSS bitcell_6t
XC57_95 BL95 BLB95 WL57 VDD VSS bitcell_6t
XC57_96 BL96 BLB96 WL57 VDD VSS bitcell_6t
XC57_97 BL97 BLB97 WL57 VDD VSS bitcell_6t
XC57_98 BL98 BLB98 WL57 VDD VSS bitcell_6t
XC57_99 BL99 BLB99 WL57 VDD VSS bitcell_6t
XC57_100 BL100 BLB100 WL57 VDD VSS bitcell_6t
XC57_101 BL101 BLB101 WL57 VDD VSS bitcell_6t
XC57_102 BL102 BLB102 WL57 VDD VSS bitcell_6t
XC57_103 BL103 BLB103 WL57 VDD VSS bitcell_6t
XC57_104 BL104 BLB104 WL57 VDD VSS bitcell_6t
XC57_105 BL105 BLB105 WL57 VDD VSS bitcell_6t
XC57_106 BL106 BLB106 WL57 VDD VSS bitcell_6t
XC57_107 BL107 BLB107 WL57 VDD VSS bitcell_6t
XC57_108 BL108 BLB108 WL57 VDD VSS bitcell_6t
XC57_109 BL109 BLB109 WL57 VDD VSS bitcell_6t
XC57_110 BL110 BLB110 WL57 VDD VSS bitcell_6t
XC57_111 BL111 BLB111 WL57 VDD VSS bitcell_6t
XC57_112 BL112 BLB112 WL57 VDD VSS bitcell_6t
XC57_113 BL113 BLB113 WL57 VDD VSS bitcell_6t
XC57_114 BL114 BLB114 WL57 VDD VSS bitcell_6t
XC57_115 BL115 BLB115 WL57 VDD VSS bitcell_6t
XC57_116 BL116 BLB116 WL57 VDD VSS bitcell_6t
XC57_117 BL117 BLB117 WL57 VDD VSS bitcell_6t
XC57_118 BL118 BLB118 WL57 VDD VSS bitcell_6t
XC57_119 BL119 BLB119 WL57 VDD VSS bitcell_6t
XC57_120 BL120 BLB120 WL57 VDD VSS bitcell_6t
XC57_121 BL121 BLB121 WL57 VDD VSS bitcell_6t
XC57_122 BL122 BLB122 WL57 VDD VSS bitcell_6t
XC57_123 BL123 BLB123 WL57 VDD VSS bitcell_6t
XC57_124 BL124 BLB124 WL57 VDD VSS bitcell_6t
XC57_125 BL125 BLB125 WL57 VDD VSS bitcell_6t
XC57_126 BL126 BLB126 WL57 VDD VSS bitcell_6t
XC57_127 BL127 BLB127 WL57 VDD VSS bitcell_6t
XC58_0 BL0 BLB0 WL58 VDD VSS bitcell_6t
XC58_1 BL1 BLB1 WL58 VDD VSS bitcell_6t
XC58_2 BL2 BLB2 WL58 VDD VSS bitcell_6t
XC58_3 BL3 BLB3 WL58 VDD VSS bitcell_6t
XC58_4 BL4 BLB4 WL58 VDD VSS bitcell_6t
XC58_5 BL5 BLB5 WL58 VDD VSS bitcell_6t
XC58_6 BL6 BLB6 WL58 VDD VSS bitcell_6t
XC58_7 BL7 BLB7 WL58 VDD VSS bitcell_6t
XC58_8 BL8 BLB8 WL58 VDD VSS bitcell_6t
XC58_9 BL9 BLB9 WL58 VDD VSS bitcell_6t
XC58_10 BL10 BLB10 WL58 VDD VSS bitcell_6t
XC58_11 BL11 BLB11 WL58 VDD VSS bitcell_6t
XC58_12 BL12 BLB12 WL58 VDD VSS bitcell_6t
XC58_13 BL13 BLB13 WL58 VDD VSS bitcell_6t
XC58_14 BL14 BLB14 WL58 VDD VSS bitcell_6t
XC58_15 BL15 BLB15 WL58 VDD VSS bitcell_6t
XC58_16 BL16 BLB16 WL58 VDD VSS bitcell_6t
XC58_17 BL17 BLB17 WL58 VDD VSS bitcell_6t
XC58_18 BL18 BLB18 WL58 VDD VSS bitcell_6t
XC58_19 BL19 BLB19 WL58 VDD VSS bitcell_6t
XC58_20 BL20 BLB20 WL58 VDD VSS bitcell_6t
XC58_21 BL21 BLB21 WL58 VDD VSS bitcell_6t
XC58_22 BL22 BLB22 WL58 VDD VSS bitcell_6t
XC58_23 BL23 BLB23 WL58 VDD VSS bitcell_6t
XC58_24 BL24 BLB24 WL58 VDD VSS bitcell_6t
XC58_25 BL25 BLB25 WL58 VDD VSS bitcell_6t
XC58_26 BL26 BLB26 WL58 VDD VSS bitcell_6t
XC58_27 BL27 BLB27 WL58 VDD VSS bitcell_6t
XC58_28 BL28 BLB28 WL58 VDD VSS bitcell_6t
XC58_29 BL29 BLB29 WL58 VDD VSS bitcell_6t
XC58_30 BL30 BLB30 WL58 VDD VSS bitcell_6t
XC58_31 BL31 BLB31 WL58 VDD VSS bitcell_6t
XC58_32 BL32 BLB32 WL58 VDD VSS bitcell_6t
XC58_33 BL33 BLB33 WL58 VDD VSS bitcell_6t
XC58_34 BL34 BLB34 WL58 VDD VSS bitcell_6t
XC58_35 BL35 BLB35 WL58 VDD VSS bitcell_6t
XC58_36 BL36 BLB36 WL58 VDD VSS bitcell_6t
XC58_37 BL37 BLB37 WL58 VDD VSS bitcell_6t
XC58_38 BL38 BLB38 WL58 VDD VSS bitcell_6t
XC58_39 BL39 BLB39 WL58 VDD VSS bitcell_6t
XC58_40 BL40 BLB40 WL58 VDD VSS bitcell_6t
XC58_41 BL41 BLB41 WL58 VDD VSS bitcell_6t
XC58_42 BL42 BLB42 WL58 VDD VSS bitcell_6t
XC58_43 BL43 BLB43 WL58 VDD VSS bitcell_6t
XC58_44 BL44 BLB44 WL58 VDD VSS bitcell_6t
XC58_45 BL45 BLB45 WL58 VDD VSS bitcell_6t
XC58_46 BL46 BLB46 WL58 VDD VSS bitcell_6t
XC58_47 BL47 BLB47 WL58 VDD VSS bitcell_6t
XC58_48 BL48 BLB48 WL58 VDD VSS bitcell_6t
XC58_49 BL49 BLB49 WL58 VDD VSS bitcell_6t
XC58_50 BL50 BLB50 WL58 VDD VSS bitcell_6t
XC58_51 BL51 BLB51 WL58 VDD VSS bitcell_6t
XC58_52 BL52 BLB52 WL58 VDD VSS bitcell_6t
XC58_53 BL53 BLB53 WL58 VDD VSS bitcell_6t
XC58_54 BL54 BLB54 WL58 VDD VSS bitcell_6t
XC58_55 BL55 BLB55 WL58 VDD VSS bitcell_6t
XC58_56 BL56 BLB56 WL58 VDD VSS bitcell_6t
XC58_57 BL57 BLB57 WL58 VDD VSS bitcell_6t
XC58_58 BL58 BLB58 WL58 VDD VSS bitcell_6t
XC58_59 BL59 BLB59 WL58 VDD VSS bitcell_6t
XC58_60 BL60 BLB60 WL58 VDD VSS bitcell_6t
XC58_61 BL61 BLB61 WL58 VDD VSS bitcell_6t
XC58_62 BL62 BLB62 WL58 VDD VSS bitcell_6t
XC58_63 BL63 BLB63 WL58 VDD VSS bitcell_6t
XC58_64 BL64 BLB64 WL58 VDD VSS bitcell_6t
XC58_65 BL65 BLB65 WL58 VDD VSS bitcell_6t
XC58_66 BL66 BLB66 WL58 VDD VSS bitcell_6t
XC58_67 BL67 BLB67 WL58 VDD VSS bitcell_6t
XC58_68 BL68 BLB68 WL58 VDD VSS bitcell_6t
XC58_69 BL69 BLB69 WL58 VDD VSS bitcell_6t
XC58_70 BL70 BLB70 WL58 VDD VSS bitcell_6t
XC58_71 BL71 BLB71 WL58 VDD VSS bitcell_6t
XC58_72 BL72 BLB72 WL58 VDD VSS bitcell_6t
XC58_73 BL73 BLB73 WL58 VDD VSS bitcell_6t
XC58_74 BL74 BLB74 WL58 VDD VSS bitcell_6t
XC58_75 BL75 BLB75 WL58 VDD VSS bitcell_6t
XC58_76 BL76 BLB76 WL58 VDD VSS bitcell_6t
XC58_77 BL77 BLB77 WL58 VDD VSS bitcell_6t
XC58_78 BL78 BLB78 WL58 VDD VSS bitcell_6t
XC58_79 BL79 BLB79 WL58 VDD VSS bitcell_6t
XC58_80 BL80 BLB80 WL58 VDD VSS bitcell_6t
XC58_81 BL81 BLB81 WL58 VDD VSS bitcell_6t
XC58_82 BL82 BLB82 WL58 VDD VSS bitcell_6t
XC58_83 BL83 BLB83 WL58 VDD VSS bitcell_6t
XC58_84 BL84 BLB84 WL58 VDD VSS bitcell_6t
XC58_85 BL85 BLB85 WL58 VDD VSS bitcell_6t
XC58_86 BL86 BLB86 WL58 VDD VSS bitcell_6t
XC58_87 BL87 BLB87 WL58 VDD VSS bitcell_6t
XC58_88 BL88 BLB88 WL58 VDD VSS bitcell_6t
XC58_89 BL89 BLB89 WL58 VDD VSS bitcell_6t
XC58_90 BL90 BLB90 WL58 VDD VSS bitcell_6t
XC58_91 BL91 BLB91 WL58 VDD VSS bitcell_6t
XC58_92 BL92 BLB92 WL58 VDD VSS bitcell_6t
XC58_93 BL93 BLB93 WL58 VDD VSS bitcell_6t
XC58_94 BL94 BLB94 WL58 VDD VSS bitcell_6t
XC58_95 BL95 BLB95 WL58 VDD VSS bitcell_6t
XC58_96 BL96 BLB96 WL58 VDD VSS bitcell_6t
XC58_97 BL97 BLB97 WL58 VDD VSS bitcell_6t
XC58_98 BL98 BLB98 WL58 VDD VSS bitcell_6t
XC58_99 BL99 BLB99 WL58 VDD VSS bitcell_6t
XC58_100 BL100 BLB100 WL58 VDD VSS bitcell_6t
XC58_101 BL101 BLB101 WL58 VDD VSS bitcell_6t
XC58_102 BL102 BLB102 WL58 VDD VSS bitcell_6t
XC58_103 BL103 BLB103 WL58 VDD VSS bitcell_6t
XC58_104 BL104 BLB104 WL58 VDD VSS bitcell_6t
XC58_105 BL105 BLB105 WL58 VDD VSS bitcell_6t
XC58_106 BL106 BLB106 WL58 VDD VSS bitcell_6t
XC58_107 BL107 BLB107 WL58 VDD VSS bitcell_6t
XC58_108 BL108 BLB108 WL58 VDD VSS bitcell_6t
XC58_109 BL109 BLB109 WL58 VDD VSS bitcell_6t
XC58_110 BL110 BLB110 WL58 VDD VSS bitcell_6t
XC58_111 BL111 BLB111 WL58 VDD VSS bitcell_6t
XC58_112 BL112 BLB112 WL58 VDD VSS bitcell_6t
XC58_113 BL113 BLB113 WL58 VDD VSS bitcell_6t
XC58_114 BL114 BLB114 WL58 VDD VSS bitcell_6t
XC58_115 BL115 BLB115 WL58 VDD VSS bitcell_6t
XC58_116 BL116 BLB116 WL58 VDD VSS bitcell_6t
XC58_117 BL117 BLB117 WL58 VDD VSS bitcell_6t
XC58_118 BL118 BLB118 WL58 VDD VSS bitcell_6t
XC58_119 BL119 BLB119 WL58 VDD VSS bitcell_6t
XC58_120 BL120 BLB120 WL58 VDD VSS bitcell_6t
XC58_121 BL121 BLB121 WL58 VDD VSS bitcell_6t
XC58_122 BL122 BLB122 WL58 VDD VSS bitcell_6t
XC58_123 BL123 BLB123 WL58 VDD VSS bitcell_6t
XC58_124 BL124 BLB124 WL58 VDD VSS bitcell_6t
XC58_125 BL125 BLB125 WL58 VDD VSS bitcell_6t
XC58_126 BL126 BLB126 WL58 VDD VSS bitcell_6t
XC58_127 BL127 BLB127 WL58 VDD VSS bitcell_6t
XC59_0 BL0 BLB0 WL59 VDD VSS bitcell_6t
XC59_1 BL1 BLB1 WL59 VDD VSS bitcell_6t
XC59_2 BL2 BLB2 WL59 VDD VSS bitcell_6t
XC59_3 BL3 BLB3 WL59 VDD VSS bitcell_6t
XC59_4 BL4 BLB4 WL59 VDD VSS bitcell_6t
XC59_5 BL5 BLB5 WL59 VDD VSS bitcell_6t
XC59_6 BL6 BLB6 WL59 VDD VSS bitcell_6t
XC59_7 BL7 BLB7 WL59 VDD VSS bitcell_6t
XC59_8 BL8 BLB8 WL59 VDD VSS bitcell_6t
XC59_9 BL9 BLB9 WL59 VDD VSS bitcell_6t
XC59_10 BL10 BLB10 WL59 VDD VSS bitcell_6t
XC59_11 BL11 BLB11 WL59 VDD VSS bitcell_6t
XC59_12 BL12 BLB12 WL59 VDD VSS bitcell_6t
XC59_13 BL13 BLB13 WL59 VDD VSS bitcell_6t
XC59_14 BL14 BLB14 WL59 VDD VSS bitcell_6t
XC59_15 BL15 BLB15 WL59 VDD VSS bitcell_6t
XC59_16 BL16 BLB16 WL59 VDD VSS bitcell_6t
XC59_17 BL17 BLB17 WL59 VDD VSS bitcell_6t
XC59_18 BL18 BLB18 WL59 VDD VSS bitcell_6t
XC59_19 BL19 BLB19 WL59 VDD VSS bitcell_6t
XC59_20 BL20 BLB20 WL59 VDD VSS bitcell_6t
XC59_21 BL21 BLB21 WL59 VDD VSS bitcell_6t
XC59_22 BL22 BLB22 WL59 VDD VSS bitcell_6t
XC59_23 BL23 BLB23 WL59 VDD VSS bitcell_6t
XC59_24 BL24 BLB24 WL59 VDD VSS bitcell_6t
XC59_25 BL25 BLB25 WL59 VDD VSS bitcell_6t
XC59_26 BL26 BLB26 WL59 VDD VSS bitcell_6t
XC59_27 BL27 BLB27 WL59 VDD VSS bitcell_6t
XC59_28 BL28 BLB28 WL59 VDD VSS bitcell_6t
XC59_29 BL29 BLB29 WL59 VDD VSS bitcell_6t
XC59_30 BL30 BLB30 WL59 VDD VSS bitcell_6t
XC59_31 BL31 BLB31 WL59 VDD VSS bitcell_6t
XC59_32 BL32 BLB32 WL59 VDD VSS bitcell_6t
XC59_33 BL33 BLB33 WL59 VDD VSS bitcell_6t
XC59_34 BL34 BLB34 WL59 VDD VSS bitcell_6t
XC59_35 BL35 BLB35 WL59 VDD VSS bitcell_6t
XC59_36 BL36 BLB36 WL59 VDD VSS bitcell_6t
XC59_37 BL37 BLB37 WL59 VDD VSS bitcell_6t
XC59_38 BL38 BLB38 WL59 VDD VSS bitcell_6t
XC59_39 BL39 BLB39 WL59 VDD VSS bitcell_6t
XC59_40 BL40 BLB40 WL59 VDD VSS bitcell_6t
XC59_41 BL41 BLB41 WL59 VDD VSS bitcell_6t
XC59_42 BL42 BLB42 WL59 VDD VSS bitcell_6t
XC59_43 BL43 BLB43 WL59 VDD VSS bitcell_6t
XC59_44 BL44 BLB44 WL59 VDD VSS bitcell_6t
XC59_45 BL45 BLB45 WL59 VDD VSS bitcell_6t
XC59_46 BL46 BLB46 WL59 VDD VSS bitcell_6t
XC59_47 BL47 BLB47 WL59 VDD VSS bitcell_6t
XC59_48 BL48 BLB48 WL59 VDD VSS bitcell_6t
XC59_49 BL49 BLB49 WL59 VDD VSS bitcell_6t
XC59_50 BL50 BLB50 WL59 VDD VSS bitcell_6t
XC59_51 BL51 BLB51 WL59 VDD VSS bitcell_6t
XC59_52 BL52 BLB52 WL59 VDD VSS bitcell_6t
XC59_53 BL53 BLB53 WL59 VDD VSS bitcell_6t
XC59_54 BL54 BLB54 WL59 VDD VSS bitcell_6t
XC59_55 BL55 BLB55 WL59 VDD VSS bitcell_6t
XC59_56 BL56 BLB56 WL59 VDD VSS bitcell_6t
XC59_57 BL57 BLB57 WL59 VDD VSS bitcell_6t
XC59_58 BL58 BLB58 WL59 VDD VSS bitcell_6t
XC59_59 BL59 BLB59 WL59 VDD VSS bitcell_6t
XC59_60 BL60 BLB60 WL59 VDD VSS bitcell_6t
XC59_61 BL61 BLB61 WL59 VDD VSS bitcell_6t
XC59_62 BL62 BLB62 WL59 VDD VSS bitcell_6t
XC59_63 BL63 BLB63 WL59 VDD VSS bitcell_6t
XC59_64 BL64 BLB64 WL59 VDD VSS bitcell_6t
XC59_65 BL65 BLB65 WL59 VDD VSS bitcell_6t
XC59_66 BL66 BLB66 WL59 VDD VSS bitcell_6t
XC59_67 BL67 BLB67 WL59 VDD VSS bitcell_6t
XC59_68 BL68 BLB68 WL59 VDD VSS bitcell_6t
XC59_69 BL69 BLB69 WL59 VDD VSS bitcell_6t
XC59_70 BL70 BLB70 WL59 VDD VSS bitcell_6t
XC59_71 BL71 BLB71 WL59 VDD VSS bitcell_6t
XC59_72 BL72 BLB72 WL59 VDD VSS bitcell_6t
XC59_73 BL73 BLB73 WL59 VDD VSS bitcell_6t
XC59_74 BL74 BLB74 WL59 VDD VSS bitcell_6t
XC59_75 BL75 BLB75 WL59 VDD VSS bitcell_6t
XC59_76 BL76 BLB76 WL59 VDD VSS bitcell_6t
XC59_77 BL77 BLB77 WL59 VDD VSS bitcell_6t
XC59_78 BL78 BLB78 WL59 VDD VSS bitcell_6t
XC59_79 BL79 BLB79 WL59 VDD VSS bitcell_6t
XC59_80 BL80 BLB80 WL59 VDD VSS bitcell_6t
XC59_81 BL81 BLB81 WL59 VDD VSS bitcell_6t
XC59_82 BL82 BLB82 WL59 VDD VSS bitcell_6t
XC59_83 BL83 BLB83 WL59 VDD VSS bitcell_6t
XC59_84 BL84 BLB84 WL59 VDD VSS bitcell_6t
XC59_85 BL85 BLB85 WL59 VDD VSS bitcell_6t
XC59_86 BL86 BLB86 WL59 VDD VSS bitcell_6t
XC59_87 BL87 BLB87 WL59 VDD VSS bitcell_6t
XC59_88 BL88 BLB88 WL59 VDD VSS bitcell_6t
XC59_89 BL89 BLB89 WL59 VDD VSS bitcell_6t
XC59_90 BL90 BLB90 WL59 VDD VSS bitcell_6t
XC59_91 BL91 BLB91 WL59 VDD VSS bitcell_6t
XC59_92 BL92 BLB92 WL59 VDD VSS bitcell_6t
XC59_93 BL93 BLB93 WL59 VDD VSS bitcell_6t
XC59_94 BL94 BLB94 WL59 VDD VSS bitcell_6t
XC59_95 BL95 BLB95 WL59 VDD VSS bitcell_6t
XC59_96 BL96 BLB96 WL59 VDD VSS bitcell_6t
XC59_97 BL97 BLB97 WL59 VDD VSS bitcell_6t
XC59_98 BL98 BLB98 WL59 VDD VSS bitcell_6t
XC59_99 BL99 BLB99 WL59 VDD VSS bitcell_6t
XC59_100 BL100 BLB100 WL59 VDD VSS bitcell_6t
XC59_101 BL101 BLB101 WL59 VDD VSS bitcell_6t
XC59_102 BL102 BLB102 WL59 VDD VSS bitcell_6t
XC59_103 BL103 BLB103 WL59 VDD VSS bitcell_6t
XC59_104 BL104 BLB104 WL59 VDD VSS bitcell_6t
XC59_105 BL105 BLB105 WL59 VDD VSS bitcell_6t
XC59_106 BL106 BLB106 WL59 VDD VSS bitcell_6t
XC59_107 BL107 BLB107 WL59 VDD VSS bitcell_6t
XC59_108 BL108 BLB108 WL59 VDD VSS bitcell_6t
XC59_109 BL109 BLB109 WL59 VDD VSS bitcell_6t
XC59_110 BL110 BLB110 WL59 VDD VSS bitcell_6t
XC59_111 BL111 BLB111 WL59 VDD VSS bitcell_6t
XC59_112 BL112 BLB112 WL59 VDD VSS bitcell_6t
XC59_113 BL113 BLB113 WL59 VDD VSS bitcell_6t
XC59_114 BL114 BLB114 WL59 VDD VSS bitcell_6t
XC59_115 BL115 BLB115 WL59 VDD VSS bitcell_6t
XC59_116 BL116 BLB116 WL59 VDD VSS bitcell_6t
XC59_117 BL117 BLB117 WL59 VDD VSS bitcell_6t
XC59_118 BL118 BLB118 WL59 VDD VSS bitcell_6t
XC59_119 BL119 BLB119 WL59 VDD VSS bitcell_6t
XC59_120 BL120 BLB120 WL59 VDD VSS bitcell_6t
XC59_121 BL121 BLB121 WL59 VDD VSS bitcell_6t
XC59_122 BL122 BLB122 WL59 VDD VSS bitcell_6t
XC59_123 BL123 BLB123 WL59 VDD VSS bitcell_6t
XC59_124 BL124 BLB124 WL59 VDD VSS bitcell_6t
XC59_125 BL125 BLB125 WL59 VDD VSS bitcell_6t
XC59_126 BL126 BLB126 WL59 VDD VSS bitcell_6t
XC59_127 BL127 BLB127 WL59 VDD VSS bitcell_6t
XC60_0 BL0 BLB0 WL60 VDD VSS bitcell_6t
XC60_1 BL1 BLB1 WL60 VDD VSS bitcell_6t
XC60_2 BL2 BLB2 WL60 VDD VSS bitcell_6t
XC60_3 BL3 BLB3 WL60 VDD VSS bitcell_6t
XC60_4 BL4 BLB4 WL60 VDD VSS bitcell_6t
XC60_5 BL5 BLB5 WL60 VDD VSS bitcell_6t
XC60_6 BL6 BLB6 WL60 VDD VSS bitcell_6t
XC60_7 BL7 BLB7 WL60 VDD VSS bitcell_6t
XC60_8 BL8 BLB8 WL60 VDD VSS bitcell_6t
XC60_9 BL9 BLB9 WL60 VDD VSS bitcell_6t
XC60_10 BL10 BLB10 WL60 VDD VSS bitcell_6t
XC60_11 BL11 BLB11 WL60 VDD VSS bitcell_6t
XC60_12 BL12 BLB12 WL60 VDD VSS bitcell_6t
XC60_13 BL13 BLB13 WL60 VDD VSS bitcell_6t
XC60_14 BL14 BLB14 WL60 VDD VSS bitcell_6t
XC60_15 BL15 BLB15 WL60 VDD VSS bitcell_6t
XC60_16 BL16 BLB16 WL60 VDD VSS bitcell_6t
XC60_17 BL17 BLB17 WL60 VDD VSS bitcell_6t
XC60_18 BL18 BLB18 WL60 VDD VSS bitcell_6t
XC60_19 BL19 BLB19 WL60 VDD VSS bitcell_6t
XC60_20 BL20 BLB20 WL60 VDD VSS bitcell_6t
XC60_21 BL21 BLB21 WL60 VDD VSS bitcell_6t
XC60_22 BL22 BLB22 WL60 VDD VSS bitcell_6t
XC60_23 BL23 BLB23 WL60 VDD VSS bitcell_6t
XC60_24 BL24 BLB24 WL60 VDD VSS bitcell_6t
XC60_25 BL25 BLB25 WL60 VDD VSS bitcell_6t
XC60_26 BL26 BLB26 WL60 VDD VSS bitcell_6t
XC60_27 BL27 BLB27 WL60 VDD VSS bitcell_6t
XC60_28 BL28 BLB28 WL60 VDD VSS bitcell_6t
XC60_29 BL29 BLB29 WL60 VDD VSS bitcell_6t
XC60_30 BL30 BLB30 WL60 VDD VSS bitcell_6t
XC60_31 BL31 BLB31 WL60 VDD VSS bitcell_6t
XC60_32 BL32 BLB32 WL60 VDD VSS bitcell_6t
XC60_33 BL33 BLB33 WL60 VDD VSS bitcell_6t
XC60_34 BL34 BLB34 WL60 VDD VSS bitcell_6t
XC60_35 BL35 BLB35 WL60 VDD VSS bitcell_6t
XC60_36 BL36 BLB36 WL60 VDD VSS bitcell_6t
XC60_37 BL37 BLB37 WL60 VDD VSS bitcell_6t
XC60_38 BL38 BLB38 WL60 VDD VSS bitcell_6t
XC60_39 BL39 BLB39 WL60 VDD VSS bitcell_6t
XC60_40 BL40 BLB40 WL60 VDD VSS bitcell_6t
XC60_41 BL41 BLB41 WL60 VDD VSS bitcell_6t
XC60_42 BL42 BLB42 WL60 VDD VSS bitcell_6t
XC60_43 BL43 BLB43 WL60 VDD VSS bitcell_6t
XC60_44 BL44 BLB44 WL60 VDD VSS bitcell_6t
XC60_45 BL45 BLB45 WL60 VDD VSS bitcell_6t
XC60_46 BL46 BLB46 WL60 VDD VSS bitcell_6t
XC60_47 BL47 BLB47 WL60 VDD VSS bitcell_6t
XC60_48 BL48 BLB48 WL60 VDD VSS bitcell_6t
XC60_49 BL49 BLB49 WL60 VDD VSS bitcell_6t
XC60_50 BL50 BLB50 WL60 VDD VSS bitcell_6t
XC60_51 BL51 BLB51 WL60 VDD VSS bitcell_6t
XC60_52 BL52 BLB52 WL60 VDD VSS bitcell_6t
XC60_53 BL53 BLB53 WL60 VDD VSS bitcell_6t
XC60_54 BL54 BLB54 WL60 VDD VSS bitcell_6t
XC60_55 BL55 BLB55 WL60 VDD VSS bitcell_6t
XC60_56 BL56 BLB56 WL60 VDD VSS bitcell_6t
XC60_57 BL57 BLB57 WL60 VDD VSS bitcell_6t
XC60_58 BL58 BLB58 WL60 VDD VSS bitcell_6t
XC60_59 BL59 BLB59 WL60 VDD VSS bitcell_6t
XC60_60 BL60 BLB60 WL60 VDD VSS bitcell_6t
XC60_61 BL61 BLB61 WL60 VDD VSS bitcell_6t
XC60_62 BL62 BLB62 WL60 VDD VSS bitcell_6t
XC60_63 BL63 BLB63 WL60 VDD VSS bitcell_6t
XC60_64 BL64 BLB64 WL60 VDD VSS bitcell_6t
XC60_65 BL65 BLB65 WL60 VDD VSS bitcell_6t
XC60_66 BL66 BLB66 WL60 VDD VSS bitcell_6t
XC60_67 BL67 BLB67 WL60 VDD VSS bitcell_6t
XC60_68 BL68 BLB68 WL60 VDD VSS bitcell_6t
XC60_69 BL69 BLB69 WL60 VDD VSS bitcell_6t
XC60_70 BL70 BLB70 WL60 VDD VSS bitcell_6t
XC60_71 BL71 BLB71 WL60 VDD VSS bitcell_6t
XC60_72 BL72 BLB72 WL60 VDD VSS bitcell_6t
XC60_73 BL73 BLB73 WL60 VDD VSS bitcell_6t
XC60_74 BL74 BLB74 WL60 VDD VSS bitcell_6t
XC60_75 BL75 BLB75 WL60 VDD VSS bitcell_6t
XC60_76 BL76 BLB76 WL60 VDD VSS bitcell_6t
XC60_77 BL77 BLB77 WL60 VDD VSS bitcell_6t
XC60_78 BL78 BLB78 WL60 VDD VSS bitcell_6t
XC60_79 BL79 BLB79 WL60 VDD VSS bitcell_6t
XC60_80 BL80 BLB80 WL60 VDD VSS bitcell_6t
XC60_81 BL81 BLB81 WL60 VDD VSS bitcell_6t
XC60_82 BL82 BLB82 WL60 VDD VSS bitcell_6t
XC60_83 BL83 BLB83 WL60 VDD VSS bitcell_6t
XC60_84 BL84 BLB84 WL60 VDD VSS bitcell_6t
XC60_85 BL85 BLB85 WL60 VDD VSS bitcell_6t
XC60_86 BL86 BLB86 WL60 VDD VSS bitcell_6t
XC60_87 BL87 BLB87 WL60 VDD VSS bitcell_6t
XC60_88 BL88 BLB88 WL60 VDD VSS bitcell_6t
XC60_89 BL89 BLB89 WL60 VDD VSS bitcell_6t
XC60_90 BL90 BLB90 WL60 VDD VSS bitcell_6t
XC60_91 BL91 BLB91 WL60 VDD VSS bitcell_6t
XC60_92 BL92 BLB92 WL60 VDD VSS bitcell_6t
XC60_93 BL93 BLB93 WL60 VDD VSS bitcell_6t
XC60_94 BL94 BLB94 WL60 VDD VSS bitcell_6t
XC60_95 BL95 BLB95 WL60 VDD VSS bitcell_6t
XC60_96 BL96 BLB96 WL60 VDD VSS bitcell_6t
XC60_97 BL97 BLB97 WL60 VDD VSS bitcell_6t
XC60_98 BL98 BLB98 WL60 VDD VSS bitcell_6t
XC60_99 BL99 BLB99 WL60 VDD VSS bitcell_6t
XC60_100 BL100 BLB100 WL60 VDD VSS bitcell_6t
XC60_101 BL101 BLB101 WL60 VDD VSS bitcell_6t
XC60_102 BL102 BLB102 WL60 VDD VSS bitcell_6t
XC60_103 BL103 BLB103 WL60 VDD VSS bitcell_6t
XC60_104 BL104 BLB104 WL60 VDD VSS bitcell_6t
XC60_105 BL105 BLB105 WL60 VDD VSS bitcell_6t
XC60_106 BL106 BLB106 WL60 VDD VSS bitcell_6t
XC60_107 BL107 BLB107 WL60 VDD VSS bitcell_6t
XC60_108 BL108 BLB108 WL60 VDD VSS bitcell_6t
XC60_109 BL109 BLB109 WL60 VDD VSS bitcell_6t
XC60_110 BL110 BLB110 WL60 VDD VSS bitcell_6t
XC60_111 BL111 BLB111 WL60 VDD VSS bitcell_6t
XC60_112 BL112 BLB112 WL60 VDD VSS bitcell_6t
XC60_113 BL113 BLB113 WL60 VDD VSS bitcell_6t
XC60_114 BL114 BLB114 WL60 VDD VSS bitcell_6t
XC60_115 BL115 BLB115 WL60 VDD VSS bitcell_6t
XC60_116 BL116 BLB116 WL60 VDD VSS bitcell_6t
XC60_117 BL117 BLB117 WL60 VDD VSS bitcell_6t
XC60_118 BL118 BLB118 WL60 VDD VSS bitcell_6t
XC60_119 BL119 BLB119 WL60 VDD VSS bitcell_6t
XC60_120 BL120 BLB120 WL60 VDD VSS bitcell_6t
XC60_121 BL121 BLB121 WL60 VDD VSS bitcell_6t
XC60_122 BL122 BLB122 WL60 VDD VSS bitcell_6t
XC60_123 BL123 BLB123 WL60 VDD VSS bitcell_6t
XC60_124 BL124 BLB124 WL60 VDD VSS bitcell_6t
XC60_125 BL125 BLB125 WL60 VDD VSS bitcell_6t
XC60_126 BL126 BLB126 WL60 VDD VSS bitcell_6t
XC60_127 BL127 BLB127 WL60 VDD VSS bitcell_6t
XC61_0 BL0 BLB0 WL61 VDD VSS bitcell_6t
XC61_1 BL1 BLB1 WL61 VDD VSS bitcell_6t
XC61_2 BL2 BLB2 WL61 VDD VSS bitcell_6t
XC61_3 BL3 BLB3 WL61 VDD VSS bitcell_6t
XC61_4 BL4 BLB4 WL61 VDD VSS bitcell_6t
XC61_5 BL5 BLB5 WL61 VDD VSS bitcell_6t
XC61_6 BL6 BLB6 WL61 VDD VSS bitcell_6t
XC61_7 BL7 BLB7 WL61 VDD VSS bitcell_6t
XC61_8 BL8 BLB8 WL61 VDD VSS bitcell_6t
XC61_9 BL9 BLB9 WL61 VDD VSS bitcell_6t
XC61_10 BL10 BLB10 WL61 VDD VSS bitcell_6t
XC61_11 BL11 BLB11 WL61 VDD VSS bitcell_6t
XC61_12 BL12 BLB12 WL61 VDD VSS bitcell_6t
XC61_13 BL13 BLB13 WL61 VDD VSS bitcell_6t
XC61_14 BL14 BLB14 WL61 VDD VSS bitcell_6t
XC61_15 BL15 BLB15 WL61 VDD VSS bitcell_6t
XC61_16 BL16 BLB16 WL61 VDD VSS bitcell_6t
XC61_17 BL17 BLB17 WL61 VDD VSS bitcell_6t
XC61_18 BL18 BLB18 WL61 VDD VSS bitcell_6t
XC61_19 BL19 BLB19 WL61 VDD VSS bitcell_6t
XC61_20 BL20 BLB20 WL61 VDD VSS bitcell_6t
XC61_21 BL21 BLB21 WL61 VDD VSS bitcell_6t
XC61_22 BL22 BLB22 WL61 VDD VSS bitcell_6t
XC61_23 BL23 BLB23 WL61 VDD VSS bitcell_6t
XC61_24 BL24 BLB24 WL61 VDD VSS bitcell_6t
XC61_25 BL25 BLB25 WL61 VDD VSS bitcell_6t
XC61_26 BL26 BLB26 WL61 VDD VSS bitcell_6t
XC61_27 BL27 BLB27 WL61 VDD VSS bitcell_6t
XC61_28 BL28 BLB28 WL61 VDD VSS bitcell_6t
XC61_29 BL29 BLB29 WL61 VDD VSS bitcell_6t
XC61_30 BL30 BLB30 WL61 VDD VSS bitcell_6t
XC61_31 BL31 BLB31 WL61 VDD VSS bitcell_6t
XC61_32 BL32 BLB32 WL61 VDD VSS bitcell_6t
XC61_33 BL33 BLB33 WL61 VDD VSS bitcell_6t
XC61_34 BL34 BLB34 WL61 VDD VSS bitcell_6t
XC61_35 BL35 BLB35 WL61 VDD VSS bitcell_6t
XC61_36 BL36 BLB36 WL61 VDD VSS bitcell_6t
XC61_37 BL37 BLB37 WL61 VDD VSS bitcell_6t
XC61_38 BL38 BLB38 WL61 VDD VSS bitcell_6t
XC61_39 BL39 BLB39 WL61 VDD VSS bitcell_6t
XC61_40 BL40 BLB40 WL61 VDD VSS bitcell_6t
XC61_41 BL41 BLB41 WL61 VDD VSS bitcell_6t
XC61_42 BL42 BLB42 WL61 VDD VSS bitcell_6t
XC61_43 BL43 BLB43 WL61 VDD VSS bitcell_6t
XC61_44 BL44 BLB44 WL61 VDD VSS bitcell_6t
XC61_45 BL45 BLB45 WL61 VDD VSS bitcell_6t
XC61_46 BL46 BLB46 WL61 VDD VSS bitcell_6t
XC61_47 BL47 BLB47 WL61 VDD VSS bitcell_6t
XC61_48 BL48 BLB48 WL61 VDD VSS bitcell_6t
XC61_49 BL49 BLB49 WL61 VDD VSS bitcell_6t
XC61_50 BL50 BLB50 WL61 VDD VSS bitcell_6t
XC61_51 BL51 BLB51 WL61 VDD VSS bitcell_6t
XC61_52 BL52 BLB52 WL61 VDD VSS bitcell_6t
XC61_53 BL53 BLB53 WL61 VDD VSS bitcell_6t
XC61_54 BL54 BLB54 WL61 VDD VSS bitcell_6t
XC61_55 BL55 BLB55 WL61 VDD VSS bitcell_6t
XC61_56 BL56 BLB56 WL61 VDD VSS bitcell_6t
XC61_57 BL57 BLB57 WL61 VDD VSS bitcell_6t
XC61_58 BL58 BLB58 WL61 VDD VSS bitcell_6t
XC61_59 BL59 BLB59 WL61 VDD VSS bitcell_6t
XC61_60 BL60 BLB60 WL61 VDD VSS bitcell_6t
XC61_61 BL61 BLB61 WL61 VDD VSS bitcell_6t
XC61_62 BL62 BLB62 WL61 VDD VSS bitcell_6t
XC61_63 BL63 BLB63 WL61 VDD VSS bitcell_6t
XC61_64 BL64 BLB64 WL61 VDD VSS bitcell_6t
XC61_65 BL65 BLB65 WL61 VDD VSS bitcell_6t
XC61_66 BL66 BLB66 WL61 VDD VSS bitcell_6t
XC61_67 BL67 BLB67 WL61 VDD VSS bitcell_6t
XC61_68 BL68 BLB68 WL61 VDD VSS bitcell_6t
XC61_69 BL69 BLB69 WL61 VDD VSS bitcell_6t
XC61_70 BL70 BLB70 WL61 VDD VSS bitcell_6t
XC61_71 BL71 BLB71 WL61 VDD VSS bitcell_6t
XC61_72 BL72 BLB72 WL61 VDD VSS bitcell_6t
XC61_73 BL73 BLB73 WL61 VDD VSS bitcell_6t
XC61_74 BL74 BLB74 WL61 VDD VSS bitcell_6t
XC61_75 BL75 BLB75 WL61 VDD VSS bitcell_6t
XC61_76 BL76 BLB76 WL61 VDD VSS bitcell_6t
XC61_77 BL77 BLB77 WL61 VDD VSS bitcell_6t
XC61_78 BL78 BLB78 WL61 VDD VSS bitcell_6t
XC61_79 BL79 BLB79 WL61 VDD VSS bitcell_6t
XC61_80 BL80 BLB80 WL61 VDD VSS bitcell_6t
XC61_81 BL81 BLB81 WL61 VDD VSS bitcell_6t
XC61_82 BL82 BLB82 WL61 VDD VSS bitcell_6t
XC61_83 BL83 BLB83 WL61 VDD VSS bitcell_6t
XC61_84 BL84 BLB84 WL61 VDD VSS bitcell_6t
XC61_85 BL85 BLB85 WL61 VDD VSS bitcell_6t
XC61_86 BL86 BLB86 WL61 VDD VSS bitcell_6t
XC61_87 BL87 BLB87 WL61 VDD VSS bitcell_6t
XC61_88 BL88 BLB88 WL61 VDD VSS bitcell_6t
XC61_89 BL89 BLB89 WL61 VDD VSS bitcell_6t
XC61_90 BL90 BLB90 WL61 VDD VSS bitcell_6t
XC61_91 BL91 BLB91 WL61 VDD VSS bitcell_6t
XC61_92 BL92 BLB92 WL61 VDD VSS bitcell_6t
XC61_93 BL93 BLB93 WL61 VDD VSS bitcell_6t
XC61_94 BL94 BLB94 WL61 VDD VSS bitcell_6t
XC61_95 BL95 BLB95 WL61 VDD VSS bitcell_6t
XC61_96 BL96 BLB96 WL61 VDD VSS bitcell_6t
XC61_97 BL97 BLB97 WL61 VDD VSS bitcell_6t
XC61_98 BL98 BLB98 WL61 VDD VSS bitcell_6t
XC61_99 BL99 BLB99 WL61 VDD VSS bitcell_6t
XC61_100 BL100 BLB100 WL61 VDD VSS bitcell_6t
XC61_101 BL101 BLB101 WL61 VDD VSS bitcell_6t
XC61_102 BL102 BLB102 WL61 VDD VSS bitcell_6t
XC61_103 BL103 BLB103 WL61 VDD VSS bitcell_6t
XC61_104 BL104 BLB104 WL61 VDD VSS bitcell_6t
XC61_105 BL105 BLB105 WL61 VDD VSS bitcell_6t
XC61_106 BL106 BLB106 WL61 VDD VSS bitcell_6t
XC61_107 BL107 BLB107 WL61 VDD VSS bitcell_6t
XC61_108 BL108 BLB108 WL61 VDD VSS bitcell_6t
XC61_109 BL109 BLB109 WL61 VDD VSS bitcell_6t
XC61_110 BL110 BLB110 WL61 VDD VSS bitcell_6t
XC61_111 BL111 BLB111 WL61 VDD VSS bitcell_6t
XC61_112 BL112 BLB112 WL61 VDD VSS bitcell_6t
XC61_113 BL113 BLB113 WL61 VDD VSS bitcell_6t
XC61_114 BL114 BLB114 WL61 VDD VSS bitcell_6t
XC61_115 BL115 BLB115 WL61 VDD VSS bitcell_6t
XC61_116 BL116 BLB116 WL61 VDD VSS bitcell_6t
XC61_117 BL117 BLB117 WL61 VDD VSS bitcell_6t
XC61_118 BL118 BLB118 WL61 VDD VSS bitcell_6t
XC61_119 BL119 BLB119 WL61 VDD VSS bitcell_6t
XC61_120 BL120 BLB120 WL61 VDD VSS bitcell_6t
XC61_121 BL121 BLB121 WL61 VDD VSS bitcell_6t
XC61_122 BL122 BLB122 WL61 VDD VSS bitcell_6t
XC61_123 BL123 BLB123 WL61 VDD VSS bitcell_6t
XC61_124 BL124 BLB124 WL61 VDD VSS bitcell_6t
XC61_125 BL125 BLB125 WL61 VDD VSS bitcell_6t
XC61_126 BL126 BLB126 WL61 VDD VSS bitcell_6t
XC61_127 BL127 BLB127 WL61 VDD VSS bitcell_6t
XC62_0 BL0 BLB0 WL62 VDD VSS bitcell_6t
XC62_1 BL1 BLB1 WL62 VDD VSS bitcell_6t
XC62_2 BL2 BLB2 WL62 VDD VSS bitcell_6t
XC62_3 BL3 BLB3 WL62 VDD VSS bitcell_6t
XC62_4 BL4 BLB4 WL62 VDD VSS bitcell_6t
XC62_5 BL5 BLB5 WL62 VDD VSS bitcell_6t
XC62_6 BL6 BLB6 WL62 VDD VSS bitcell_6t
XC62_7 BL7 BLB7 WL62 VDD VSS bitcell_6t
XC62_8 BL8 BLB8 WL62 VDD VSS bitcell_6t
XC62_9 BL9 BLB9 WL62 VDD VSS bitcell_6t
XC62_10 BL10 BLB10 WL62 VDD VSS bitcell_6t
XC62_11 BL11 BLB11 WL62 VDD VSS bitcell_6t
XC62_12 BL12 BLB12 WL62 VDD VSS bitcell_6t
XC62_13 BL13 BLB13 WL62 VDD VSS bitcell_6t
XC62_14 BL14 BLB14 WL62 VDD VSS bitcell_6t
XC62_15 BL15 BLB15 WL62 VDD VSS bitcell_6t
XC62_16 BL16 BLB16 WL62 VDD VSS bitcell_6t
XC62_17 BL17 BLB17 WL62 VDD VSS bitcell_6t
XC62_18 BL18 BLB18 WL62 VDD VSS bitcell_6t
XC62_19 BL19 BLB19 WL62 VDD VSS bitcell_6t
XC62_20 BL20 BLB20 WL62 VDD VSS bitcell_6t
XC62_21 BL21 BLB21 WL62 VDD VSS bitcell_6t
XC62_22 BL22 BLB22 WL62 VDD VSS bitcell_6t
XC62_23 BL23 BLB23 WL62 VDD VSS bitcell_6t
XC62_24 BL24 BLB24 WL62 VDD VSS bitcell_6t
XC62_25 BL25 BLB25 WL62 VDD VSS bitcell_6t
XC62_26 BL26 BLB26 WL62 VDD VSS bitcell_6t
XC62_27 BL27 BLB27 WL62 VDD VSS bitcell_6t
XC62_28 BL28 BLB28 WL62 VDD VSS bitcell_6t
XC62_29 BL29 BLB29 WL62 VDD VSS bitcell_6t
XC62_30 BL30 BLB30 WL62 VDD VSS bitcell_6t
XC62_31 BL31 BLB31 WL62 VDD VSS bitcell_6t
XC62_32 BL32 BLB32 WL62 VDD VSS bitcell_6t
XC62_33 BL33 BLB33 WL62 VDD VSS bitcell_6t
XC62_34 BL34 BLB34 WL62 VDD VSS bitcell_6t
XC62_35 BL35 BLB35 WL62 VDD VSS bitcell_6t
XC62_36 BL36 BLB36 WL62 VDD VSS bitcell_6t
XC62_37 BL37 BLB37 WL62 VDD VSS bitcell_6t
XC62_38 BL38 BLB38 WL62 VDD VSS bitcell_6t
XC62_39 BL39 BLB39 WL62 VDD VSS bitcell_6t
XC62_40 BL40 BLB40 WL62 VDD VSS bitcell_6t
XC62_41 BL41 BLB41 WL62 VDD VSS bitcell_6t
XC62_42 BL42 BLB42 WL62 VDD VSS bitcell_6t
XC62_43 BL43 BLB43 WL62 VDD VSS bitcell_6t
XC62_44 BL44 BLB44 WL62 VDD VSS bitcell_6t
XC62_45 BL45 BLB45 WL62 VDD VSS bitcell_6t
XC62_46 BL46 BLB46 WL62 VDD VSS bitcell_6t
XC62_47 BL47 BLB47 WL62 VDD VSS bitcell_6t
XC62_48 BL48 BLB48 WL62 VDD VSS bitcell_6t
XC62_49 BL49 BLB49 WL62 VDD VSS bitcell_6t
XC62_50 BL50 BLB50 WL62 VDD VSS bitcell_6t
XC62_51 BL51 BLB51 WL62 VDD VSS bitcell_6t
XC62_52 BL52 BLB52 WL62 VDD VSS bitcell_6t
XC62_53 BL53 BLB53 WL62 VDD VSS bitcell_6t
XC62_54 BL54 BLB54 WL62 VDD VSS bitcell_6t
XC62_55 BL55 BLB55 WL62 VDD VSS bitcell_6t
XC62_56 BL56 BLB56 WL62 VDD VSS bitcell_6t
XC62_57 BL57 BLB57 WL62 VDD VSS bitcell_6t
XC62_58 BL58 BLB58 WL62 VDD VSS bitcell_6t
XC62_59 BL59 BLB59 WL62 VDD VSS bitcell_6t
XC62_60 BL60 BLB60 WL62 VDD VSS bitcell_6t
XC62_61 BL61 BLB61 WL62 VDD VSS bitcell_6t
XC62_62 BL62 BLB62 WL62 VDD VSS bitcell_6t
XC62_63 BL63 BLB63 WL62 VDD VSS bitcell_6t
XC62_64 BL64 BLB64 WL62 VDD VSS bitcell_6t
XC62_65 BL65 BLB65 WL62 VDD VSS bitcell_6t
XC62_66 BL66 BLB66 WL62 VDD VSS bitcell_6t
XC62_67 BL67 BLB67 WL62 VDD VSS bitcell_6t
XC62_68 BL68 BLB68 WL62 VDD VSS bitcell_6t
XC62_69 BL69 BLB69 WL62 VDD VSS bitcell_6t
XC62_70 BL70 BLB70 WL62 VDD VSS bitcell_6t
XC62_71 BL71 BLB71 WL62 VDD VSS bitcell_6t
XC62_72 BL72 BLB72 WL62 VDD VSS bitcell_6t
XC62_73 BL73 BLB73 WL62 VDD VSS bitcell_6t
XC62_74 BL74 BLB74 WL62 VDD VSS bitcell_6t
XC62_75 BL75 BLB75 WL62 VDD VSS bitcell_6t
XC62_76 BL76 BLB76 WL62 VDD VSS bitcell_6t
XC62_77 BL77 BLB77 WL62 VDD VSS bitcell_6t
XC62_78 BL78 BLB78 WL62 VDD VSS bitcell_6t
XC62_79 BL79 BLB79 WL62 VDD VSS bitcell_6t
XC62_80 BL80 BLB80 WL62 VDD VSS bitcell_6t
XC62_81 BL81 BLB81 WL62 VDD VSS bitcell_6t
XC62_82 BL82 BLB82 WL62 VDD VSS bitcell_6t
XC62_83 BL83 BLB83 WL62 VDD VSS bitcell_6t
XC62_84 BL84 BLB84 WL62 VDD VSS bitcell_6t
XC62_85 BL85 BLB85 WL62 VDD VSS bitcell_6t
XC62_86 BL86 BLB86 WL62 VDD VSS bitcell_6t
XC62_87 BL87 BLB87 WL62 VDD VSS bitcell_6t
XC62_88 BL88 BLB88 WL62 VDD VSS bitcell_6t
XC62_89 BL89 BLB89 WL62 VDD VSS bitcell_6t
XC62_90 BL90 BLB90 WL62 VDD VSS bitcell_6t
XC62_91 BL91 BLB91 WL62 VDD VSS bitcell_6t
XC62_92 BL92 BLB92 WL62 VDD VSS bitcell_6t
XC62_93 BL93 BLB93 WL62 VDD VSS bitcell_6t
XC62_94 BL94 BLB94 WL62 VDD VSS bitcell_6t
XC62_95 BL95 BLB95 WL62 VDD VSS bitcell_6t
XC62_96 BL96 BLB96 WL62 VDD VSS bitcell_6t
XC62_97 BL97 BLB97 WL62 VDD VSS bitcell_6t
XC62_98 BL98 BLB98 WL62 VDD VSS bitcell_6t
XC62_99 BL99 BLB99 WL62 VDD VSS bitcell_6t
XC62_100 BL100 BLB100 WL62 VDD VSS bitcell_6t
XC62_101 BL101 BLB101 WL62 VDD VSS bitcell_6t
XC62_102 BL102 BLB102 WL62 VDD VSS bitcell_6t
XC62_103 BL103 BLB103 WL62 VDD VSS bitcell_6t
XC62_104 BL104 BLB104 WL62 VDD VSS bitcell_6t
XC62_105 BL105 BLB105 WL62 VDD VSS bitcell_6t
XC62_106 BL106 BLB106 WL62 VDD VSS bitcell_6t
XC62_107 BL107 BLB107 WL62 VDD VSS bitcell_6t
XC62_108 BL108 BLB108 WL62 VDD VSS bitcell_6t
XC62_109 BL109 BLB109 WL62 VDD VSS bitcell_6t
XC62_110 BL110 BLB110 WL62 VDD VSS bitcell_6t
XC62_111 BL111 BLB111 WL62 VDD VSS bitcell_6t
XC62_112 BL112 BLB112 WL62 VDD VSS bitcell_6t
XC62_113 BL113 BLB113 WL62 VDD VSS bitcell_6t
XC62_114 BL114 BLB114 WL62 VDD VSS bitcell_6t
XC62_115 BL115 BLB115 WL62 VDD VSS bitcell_6t
XC62_116 BL116 BLB116 WL62 VDD VSS bitcell_6t
XC62_117 BL117 BLB117 WL62 VDD VSS bitcell_6t
XC62_118 BL118 BLB118 WL62 VDD VSS bitcell_6t
XC62_119 BL119 BLB119 WL62 VDD VSS bitcell_6t
XC62_120 BL120 BLB120 WL62 VDD VSS bitcell_6t
XC62_121 BL121 BLB121 WL62 VDD VSS bitcell_6t
XC62_122 BL122 BLB122 WL62 VDD VSS bitcell_6t
XC62_123 BL123 BLB123 WL62 VDD VSS bitcell_6t
XC62_124 BL124 BLB124 WL62 VDD VSS bitcell_6t
XC62_125 BL125 BLB125 WL62 VDD VSS bitcell_6t
XC62_126 BL126 BLB126 WL62 VDD VSS bitcell_6t
XC62_127 BL127 BLB127 WL62 VDD VSS bitcell_6t
XC63_0 BL0 BLB0 WL63 VDD VSS bitcell_6t
XC63_1 BL1 BLB1 WL63 VDD VSS bitcell_6t
XC63_2 BL2 BLB2 WL63 VDD VSS bitcell_6t
XC63_3 BL3 BLB3 WL63 VDD VSS bitcell_6t
XC63_4 BL4 BLB4 WL63 VDD VSS bitcell_6t
XC63_5 BL5 BLB5 WL63 VDD VSS bitcell_6t
XC63_6 BL6 BLB6 WL63 VDD VSS bitcell_6t
XC63_7 BL7 BLB7 WL63 VDD VSS bitcell_6t
XC63_8 BL8 BLB8 WL63 VDD VSS bitcell_6t
XC63_9 BL9 BLB9 WL63 VDD VSS bitcell_6t
XC63_10 BL10 BLB10 WL63 VDD VSS bitcell_6t
XC63_11 BL11 BLB11 WL63 VDD VSS bitcell_6t
XC63_12 BL12 BLB12 WL63 VDD VSS bitcell_6t
XC63_13 BL13 BLB13 WL63 VDD VSS bitcell_6t
XC63_14 BL14 BLB14 WL63 VDD VSS bitcell_6t
XC63_15 BL15 BLB15 WL63 VDD VSS bitcell_6t
XC63_16 BL16 BLB16 WL63 VDD VSS bitcell_6t
XC63_17 BL17 BLB17 WL63 VDD VSS bitcell_6t
XC63_18 BL18 BLB18 WL63 VDD VSS bitcell_6t
XC63_19 BL19 BLB19 WL63 VDD VSS bitcell_6t
XC63_20 BL20 BLB20 WL63 VDD VSS bitcell_6t
XC63_21 BL21 BLB21 WL63 VDD VSS bitcell_6t
XC63_22 BL22 BLB22 WL63 VDD VSS bitcell_6t
XC63_23 BL23 BLB23 WL63 VDD VSS bitcell_6t
XC63_24 BL24 BLB24 WL63 VDD VSS bitcell_6t
XC63_25 BL25 BLB25 WL63 VDD VSS bitcell_6t
XC63_26 BL26 BLB26 WL63 VDD VSS bitcell_6t
XC63_27 BL27 BLB27 WL63 VDD VSS bitcell_6t
XC63_28 BL28 BLB28 WL63 VDD VSS bitcell_6t
XC63_29 BL29 BLB29 WL63 VDD VSS bitcell_6t
XC63_30 BL30 BLB30 WL63 VDD VSS bitcell_6t
XC63_31 BL31 BLB31 WL63 VDD VSS bitcell_6t
XC63_32 BL32 BLB32 WL63 VDD VSS bitcell_6t
XC63_33 BL33 BLB33 WL63 VDD VSS bitcell_6t
XC63_34 BL34 BLB34 WL63 VDD VSS bitcell_6t
XC63_35 BL35 BLB35 WL63 VDD VSS bitcell_6t
XC63_36 BL36 BLB36 WL63 VDD VSS bitcell_6t
XC63_37 BL37 BLB37 WL63 VDD VSS bitcell_6t
XC63_38 BL38 BLB38 WL63 VDD VSS bitcell_6t
XC63_39 BL39 BLB39 WL63 VDD VSS bitcell_6t
XC63_40 BL40 BLB40 WL63 VDD VSS bitcell_6t
XC63_41 BL41 BLB41 WL63 VDD VSS bitcell_6t
XC63_42 BL42 BLB42 WL63 VDD VSS bitcell_6t
XC63_43 BL43 BLB43 WL63 VDD VSS bitcell_6t
XC63_44 BL44 BLB44 WL63 VDD VSS bitcell_6t
XC63_45 BL45 BLB45 WL63 VDD VSS bitcell_6t
XC63_46 BL46 BLB46 WL63 VDD VSS bitcell_6t
XC63_47 BL47 BLB47 WL63 VDD VSS bitcell_6t
XC63_48 BL48 BLB48 WL63 VDD VSS bitcell_6t
XC63_49 BL49 BLB49 WL63 VDD VSS bitcell_6t
XC63_50 BL50 BLB50 WL63 VDD VSS bitcell_6t
XC63_51 BL51 BLB51 WL63 VDD VSS bitcell_6t
XC63_52 BL52 BLB52 WL63 VDD VSS bitcell_6t
XC63_53 BL53 BLB53 WL63 VDD VSS bitcell_6t
XC63_54 BL54 BLB54 WL63 VDD VSS bitcell_6t
XC63_55 BL55 BLB55 WL63 VDD VSS bitcell_6t
XC63_56 BL56 BLB56 WL63 VDD VSS bitcell_6t
XC63_57 BL57 BLB57 WL63 VDD VSS bitcell_6t
XC63_58 BL58 BLB58 WL63 VDD VSS bitcell_6t
XC63_59 BL59 BLB59 WL63 VDD VSS bitcell_6t
XC63_60 BL60 BLB60 WL63 VDD VSS bitcell_6t
XC63_61 BL61 BLB61 WL63 VDD VSS bitcell_6t
XC63_62 BL62 BLB62 WL63 VDD VSS bitcell_6t
XC63_63 BL63 BLB63 WL63 VDD VSS bitcell_6t
XC63_64 BL64 BLB64 WL63 VDD VSS bitcell_6t
XC63_65 BL65 BLB65 WL63 VDD VSS bitcell_6t
XC63_66 BL66 BLB66 WL63 VDD VSS bitcell_6t
XC63_67 BL67 BLB67 WL63 VDD VSS bitcell_6t
XC63_68 BL68 BLB68 WL63 VDD VSS bitcell_6t
XC63_69 BL69 BLB69 WL63 VDD VSS bitcell_6t
XC63_70 BL70 BLB70 WL63 VDD VSS bitcell_6t
XC63_71 BL71 BLB71 WL63 VDD VSS bitcell_6t
XC63_72 BL72 BLB72 WL63 VDD VSS bitcell_6t
XC63_73 BL73 BLB73 WL63 VDD VSS bitcell_6t
XC63_74 BL74 BLB74 WL63 VDD VSS bitcell_6t
XC63_75 BL75 BLB75 WL63 VDD VSS bitcell_6t
XC63_76 BL76 BLB76 WL63 VDD VSS bitcell_6t
XC63_77 BL77 BLB77 WL63 VDD VSS bitcell_6t
XC63_78 BL78 BLB78 WL63 VDD VSS bitcell_6t
XC63_79 BL79 BLB79 WL63 VDD VSS bitcell_6t
XC63_80 BL80 BLB80 WL63 VDD VSS bitcell_6t
XC63_81 BL81 BLB81 WL63 VDD VSS bitcell_6t
XC63_82 BL82 BLB82 WL63 VDD VSS bitcell_6t
XC63_83 BL83 BLB83 WL63 VDD VSS bitcell_6t
XC63_84 BL84 BLB84 WL63 VDD VSS bitcell_6t
XC63_85 BL85 BLB85 WL63 VDD VSS bitcell_6t
XC63_86 BL86 BLB86 WL63 VDD VSS bitcell_6t
XC63_87 BL87 BLB87 WL63 VDD VSS bitcell_6t
XC63_88 BL88 BLB88 WL63 VDD VSS bitcell_6t
XC63_89 BL89 BLB89 WL63 VDD VSS bitcell_6t
XC63_90 BL90 BLB90 WL63 VDD VSS bitcell_6t
XC63_91 BL91 BLB91 WL63 VDD VSS bitcell_6t
XC63_92 BL92 BLB92 WL63 VDD VSS bitcell_6t
XC63_93 BL93 BLB93 WL63 VDD VSS bitcell_6t
XC63_94 BL94 BLB94 WL63 VDD VSS bitcell_6t
XC63_95 BL95 BLB95 WL63 VDD VSS bitcell_6t
XC63_96 BL96 BLB96 WL63 VDD VSS bitcell_6t
XC63_97 BL97 BLB97 WL63 VDD VSS bitcell_6t
XC63_98 BL98 BLB98 WL63 VDD VSS bitcell_6t
XC63_99 BL99 BLB99 WL63 VDD VSS bitcell_6t
XC63_100 BL100 BLB100 WL63 VDD VSS bitcell_6t
XC63_101 BL101 BLB101 WL63 VDD VSS bitcell_6t
XC63_102 BL102 BLB102 WL63 VDD VSS bitcell_6t
XC63_103 BL103 BLB103 WL63 VDD VSS bitcell_6t
XC63_104 BL104 BLB104 WL63 VDD VSS bitcell_6t
XC63_105 BL105 BLB105 WL63 VDD VSS bitcell_6t
XC63_106 BL106 BLB106 WL63 VDD VSS bitcell_6t
XC63_107 BL107 BLB107 WL63 VDD VSS bitcell_6t
XC63_108 BL108 BLB108 WL63 VDD VSS bitcell_6t
XC63_109 BL109 BLB109 WL63 VDD VSS bitcell_6t
XC63_110 BL110 BLB110 WL63 VDD VSS bitcell_6t
XC63_111 BL111 BLB111 WL63 VDD VSS bitcell_6t
XC63_112 BL112 BLB112 WL63 VDD VSS bitcell_6t
XC63_113 BL113 BLB113 WL63 VDD VSS bitcell_6t
XC63_114 BL114 BLB114 WL63 VDD VSS bitcell_6t
XC63_115 BL115 BLB115 WL63 VDD VSS bitcell_6t
XC63_116 BL116 BLB116 WL63 VDD VSS bitcell_6t
XC63_117 BL117 BLB117 WL63 VDD VSS bitcell_6t
XC63_118 BL118 BLB118 WL63 VDD VSS bitcell_6t
XC63_119 BL119 BLB119 WL63 VDD VSS bitcell_6t
XC63_120 BL120 BLB120 WL63 VDD VSS bitcell_6t
XC63_121 BL121 BLB121 WL63 VDD VSS bitcell_6t
XC63_122 BL122 BLB122 WL63 VDD VSS bitcell_6t
XC63_123 BL123 BLB123 WL63 VDD VSS bitcell_6t
XC63_124 BL124 BLB124 WL63 VDD VSS bitcell_6t
XC63_125 BL125 BLB125 WL63 VDD VSS bitcell_6t
XC63_126 BL126 BLB126 WL63 VDD VSS bitcell_6t
XC63_127 BL127 BLB127 WL63 VDD VSS bitcell_6t
X178_precharge BL0 BLB0 PCHB VDD sram_precharge
X179_precharge BL1 BLB1 PCHB VDD sram_precharge
X180_precharge BL2 BLB2 PCHB VDD sram_precharge
X181_precharge BL3 BLB3 PCHB VDD sram_precharge
X182_precharge BL4 BLB4 PCHB VDD sram_precharge
X183_precharge BL5 BLB5 PCHB VDD sram_precharge
X184_precharge BL6 BLB6 PCHB VDD sram_precharge
X185_precharge BL7 BLB7 PCHB VDD sram_precharge
X186_precharge BL8 BLB8 PCHB VDD sram_precharge
X187_precharge BL9 BLB9 PCHB VDD sram_precharge
X188_precharge BL10 BLB10 PCHB VDD sram_precharge
X189_precharge BL11 BLB11 PCHB VDD sram_precharge
X190_precharge BL12 BLB12 PCHB VDD sram_precharge
X191_precharge BL13 BLB13 PCHB VDD sram_precharge
X192_precharge BL14 BLB14 PCHB VDD sram_precharge
X193_precharge BL15 BLB15 PCHB VDD sram_precharge
X194_precharge BL16 BLB16 PCHB VDD sram_precharge
X195_precharge BL17 BLB17 PCHB VDD sram_precharge
X196_precharge BL18 BLB18 PCHB VDD sram_precharge
X197_precharge BL19 BLB19 PCHB VDD sram_precharge
X198_precharge BL20 BLB20 PCHB VDD sram_precharge
X199_precharge BL21 BLB21 PCHB VDD sram_precharge
X200_precharge BL22 BLB22 PCHB VDD sram_precharge
X201_precharge BL23 BLB23 PCHB VDD sram_precharge
X202_precharge BL24 BLB24 PCHB VDD sram_precharge
X203_precharge BL25 BLB25 PCHB VDD sram_precharge
X204_precharge BL26 BLB26 PCHB VDD sram_precharge
X205_precharge BL27 BLB27 PCHB VDD sram_precharge
X206_precharge BL28 BLB28 PCHB VDD sram_precharge
X207_precharge BL29 BLB29 PCHB VDD sram_precharge
X208_precharge BL30 BLB30 PCHB VDD sram_precharge
X209_precharge BL31 BLB31 PCHB VDD sram_precharge
X210_precharge BL32 BLB32 PCHB VDD sram_precharge
X211_precharge BL33 BLB33 PCHB VDD sram_precharge
X212_precharge BL34 BLB34 PCHB VDD sram_precharge
X213_precharge BL35 BLB35 PCHB VDD sram_precharge
X214_precharge BL36 BLB36 PCHB VDD sram_precharge
X215_precharge BL37 BLB37 PCHB VDD sram_precharge
X216_precharge BL38 BLB38 PCHB VDD sram_precharge
X217_precharge BL39 BLB39 PCHB VDD sram_precharge
X218_precharge BL40 BLB40 PCHB VDD sram_precharge
X219_precharge BL41 BLB41 PCHB VDD sram_precharge
X220_precharge BL42 BLB42 PCHB VDD sram_precharge
X221_precharge BL43 BLB43 PCHB VDD sram_precharge
X222_precharge BL44 BLB44 PCHB VDD sram_precharge
X223_precharge BL45 BLB45 PCHB VDD sram_precharge
X224_precharge BL46 BLB46 PCHB VDD sram_precharge
X225_precharge BL47 BLB47 PCHB VDD sram_precharge
X226_precharge BL48 BLB48 PCHB VDD sram_precharge
X227_precharge BL49 BLB49 PCHB VDD sram_precharge
X228_precharge BL50 BLB50 PCHB VDD sram_precharge
X229_precharge BL51 BLB51 PCHB VDD sram_precharge
X230_precharge BL52 BLB52 PCHB VDD sram_precharge
X231_precharge BL53 BLB53 PCHB VDD sram_precharge
X232_precharge BL54 BLB54 PCHB VDD sram_precharge
X233_precharge BL55 BLB55 PCHB VDD sram_precharge
X234_precharge BL56 BLB56 PCHB VDD sram_precharge
X235_precharge BL57 BLB57 PCHB VDD sram_precharge
X236_precharge BL58 BLB58 PCHB VDD sram_precharge
X237_precharge BL59 BLB59 PCHB VDD sram_precharge
X238_precharge BL60 BLB60 PCHB VDD sram_precharge
X239_precharge BL61 BLB61 PCHB VDD sram_precharge
X240_precharge BL62 BLB62 PCHB VDD sram_precharge
X241_precharge BL63 BLB63 PCHB VDD sram_precharge
X242_precharge BL64 BLB64 PCHB VDD sram_precharge
X243_precharge BL65 BLB65 PCHB VDD sram_precharge
X244_precharge BL66 BLB66 PCHB VDD sram_precharge
X245_precharge BL67 BLB67 PCHB VDD sram_precharge
X246_precharge BL68 BLB68 PCHB VDD sram_precharge
X247_precharge BL69 BLB69 PCHB VDD sram_precharge
X248_precharge BL70 BLB70 PCHB VDD sram_precharge
X249_precharge BL71 BLB71 PCHB VDD sram_precharge
X250_precharge BL72 BLB72 PCHB VDD sram_precharge
X251_precharge BL73 BLB73 PCHB VDD sram_precharge
X252_precharge BL74 BLB74 PCHB VDD sram_precharge
X253_precharge BL75 BLB75 PCHB VDD sram_precharge
X254_precharge BL76 BLB76 PCHB VDD sram_precharge
X255_precharge BL77 BLB77 PCHB VDD sram_precharge
X256_precharge BL78 BLB78 PCHB VDD sram_precharge
X257_precharge BL79 BLB79 PCHB VDD sram_precharge
X258_precharge BL80 BLB80 PCHB VDD sram_precharge
X259_precharge BL81 BLB81 PCHB VDD sram_precharge
X260_precharge BL82 BLB82 PCHB VDD sram_precharge
X261_precharge BL83 BLB83 PCHB VDD sram_precharge
X262_precharge BL84 BLB84 PCHB VDD sram_precharge
X263_precharge BL85 BLB85 PCHB VDD sram_precharge
X264_precharge BL86 BLB86 PCHB VDD sram_precharge
X265_precharge BL87 BLB87 PCHB VDD sram_precharge
X266_precharge BL88 BLB88 PCHB VDD sram_precharge
X267_precharge BL89 BLB89 PCHB VDD sram_precharge
X268_precharge BL90 BLB90 PCHB VDD sram_precharge
X269_precharge BL91 BLB91 PCHB VDD sram_precharge
X270_precharge BL92 BLB92 PCHB VDD sram_precharge
X271_precharge BL93 BLB93 PCHB VDD sram_precharge
X272_precharge BL94 BLB94 PCHB VDD sram_precharge
X273_precharge BL95 BLB95 PCHB VDD sram_precharge
X274_precharge BL96 BLB96 PCHB VDD sram_precharge
X275_precharge BL97 BLB97 PCHB VDD sram_precharge
X276_precharge BL98 BLB98 PCHB VDD sram_precharge
X277_precharge BL99 BLB99 PCHB VDD sram_precharge
X278_precharge BL100 BLB100 PCHB VDD sram_precharge
X279_precharge BL101 BLB101 PCHB VDD sram_precharge
X280_precharge BL102 BLB102 PCHB VDD sram_precharge
X281_precharge BL103 BLB103 PCHB VDD sram_precharge
X282_precharge BL104 BLB104 PCHB VDD sram_precharge
X283_precharge BL105 BLB105 PCHB VDD sram_precharge
X284_precharge BL106 BLB106 PCHB VDD sram_precharge
X285_precharge BL107 BLB107 PCHB VDD sram_precharge
X286_precharge BL108 BLB108 PCHB VDD sram_precharge
X287_precharge BL109 BLB109 PCHB VDD sram_precharge
X288_precharge BL110 BLB110 PCHB VDD sram_precharge
X289_precharge BL111 BLB111 PCHB VDD sram_precharge
X290_precharge BL112 BLB112 PCHB VDD sram_precharge
X291_precharge BL113 BLB113 PCHB VDD sram_precharge
X292_precharge BL114 BLB114 PCHB VDD sram_precharge
X293_precharge BL115 BLB115 PCHB VDD sram_precharge
X294_precharge BL116 BLB116 PCHB VDD sram_precharge
X295_precharge BL117 BLB117 PCHB VDD sram_precharge
X296_precharge BL118 BLB118 PCHB VDD sram_precharge
X297_precharge BL119 BLB119 PCHB VDD sram_precharge
X298_precharge BL120 BLB120 PCHB VDD sram_precharge
X299_precharge BL121 BLB121 PCHB VDD sram_precharge
X300_precharge BL122 BLB122 PCHB VDD sram_precharge
X301_precharge BL123 BLB123 PCHB VDD sram_precharge
X302_precharge BL124 BLB124 PCHB VDD sram_precharge
X303_precharge BL125 BLB125 PCHB VDD sram_precharge
X304_precharge BL126 BLB126 PCHB VDD sram_precharge
X305_precharge BL127 BLB127 PCHB VDD sram_precharge
X306_colmux BL0 BLB0 SBL0 SBLB0 CS0 VSS sram_colmux
X307_colmux BL1 BLB1 SBL0 SBLB0 CS1 VSS sram_colmux
X308_colmux BL2 BLB2 SBL0 SBLB0 CS2 VSS sram_colmux
X309_colmux BL3 BLB3 SBL0 SBLB0 CS3 VSS sram_colmux
X310_colmux BL4 BLB4 SBL1 SBLB1 CS0 VSS sram_colmux
X311_colmux BL5 BLB5 SBL1 SBLB1 CS1 VSS sram_colmux
X312_colmux BL6 BLB6 SBL1 SBLB1 CS2 VSS sram_colmux
X313_colmux BL7 BLB7 SBL1 SBLB1 CS3 VSS sram_colmux
X314_colmux BL8 BLB8 SBL2 SBLB2 CS0 VSS sram_colmux
X315_colmux BL9 BLB9 SBL2 SBLB2 CS1 VSS sram_colmux
X316_colmux BL10 BLB10 SBL2 SBLB2 CS2 VSS sram_colmux
X317_colmux BL11 BLB11 SBL2 SBLB2 CS3 VSS sram_colmux
X318_colmux BL12 BLB12 SBL3 SBLB3 CS0 VSS sram_colmux
X319_colmux BL13 BLB13 SBL3 SBLB3 CS1 VSS sram_colmux
X320_colmux BL14 BLB14 SBL3 SBLB3 CS2 VSS sram_colmux
X321_colmux BL15 BLB15 SBL3 SBLB3 CS3 VSS sram_colmux
X322_colmux BL16 BLB16 SBL4 SBLB4 CS0 VSS sram_colmux
X323_colmux BL17 BLB17 SBL4 SBLB4 CS1 VSS sram_colmux
X324_colmux BL18 BLB18 SBL4 SBLB4 CS2 VSS sram_colmux
X325_colmux BL19 BLB19 SBL4 SBLB4 CS3 VSS sram_colmux
X326_colmux BL20 BLB20 SBL5 SBLB5 CS0 VSS sram_colmux
X327_colmux BL21 BLB21 SBL5 SBLB5 CS1 VSS sram_colmux
X328_colmux BL22 BLB22 SBL5 SBLB5 CS2 VSS sram_colmux
X329_colmux BL23 BLB23 SBL5 SBLB5 CS3 VSS sram_colmux
X330_colmux BL24 BLB24 SBL6 SBLB6 CS0 VSS sram_colmux
X331_colmux BL25 BLB25 SBL6 SBLB6 CS1 VSS sram_colmux
X332_colmux BL26 BLB26 SBL6 SBLB6 CS2 VSS sram_colmux
X333_colmux BL27 BLB27 SBL6 SBLB6 CS3 VSS sram_colmux
X334_colmux BL28 BLB28 SBL7 SBLB7 CS0 VSS sram_colmux
X335_colmux BL29 BLB29 SBL7 SBLB7 CS1 VSS sram_colmux
X336_colmux BL30 BLB30 SBL7 SBLB7 CS2 VSS sram_colmux
X337_colmux BL31 BLB31 SBL7 SBLB7 CS3 VSS sram_colmux
X338_colmux BL32 BLB32 SBL8 SBLB8 CS0 VSS sram_colmux
X339_colmux BL33 BLB33 SBL8 SBLB8 CS1 VSS sram_colmux
X340_colmux BL34 BLB34 SBL8 SBLB8 CS2 VSS sram_colmux
X341_colmux BL35 BLB35 SBL8 SBLB8 CS3 VSS sram_colmux
X342_colmux BL36 BLB36 SBL9 SBLB9 CS0 VSS sram_colmux
X343_colmux BL37 BLB37 SBL9 SBLB9 CS1 VSS sram_colmux
X344_colmux BL38 BLB38 SBL9 SBLB9 CS2 VSS sram_colmux
X345_colmux BL39 BLB39 SBL9 SBLB9 CS3 VSS sram_colmux
X346_colmux BL40 BLB40 SBL10 SBLB10 CS0 VSS sram_colmux
X347_colmux BL41 BLB41 SBL10 SBLB10 CS1 VSS sram_colmux
X348_colmux BL42 BLB42 SBL10 SBLB10 CS2 VSS sram_colmux
X349_colmux BL43 BLB43 SBL10 SBLB10 CS3 VSS sram_colmux
X350_colmux BL44 BLB44 SBL11 SBLB11 CS0 VSS sram_colmux
X351_colmux BL45 BLB45 SBL11 SBLB11 CS1 VSS sram_colmux
X352_colmux BL46 BLB46 SBL11 SBLB11 CS2 VSS sram_colmux
X353_colmux BL47 BLB47 SBL11 SBLB11 CS3 VSS sram_colmux
X354_colmux BL48 BLB48 SBL12 SBLB12 CS0 VSS sram_colmux
X355_colmux BL49 BLB49 SBL12 SBLB12 CS1 VSS sram_colmux
X356_colmux BL50 BLB50 SBL12 SBLB12 CS2 VSS sram_colmux
X357_colmux BL51 BLB51 SBL12 SBLB12 CS3 VSS sram_colmux
X358_colmux BL52 BLB52 SBL13 SBLB13 CS0 VSS sram_colmux
X359_colmux BL53 BLB53 SBL13 SBLB13 CS1 VSS sram_colmux
X360_colmux BL54 BLB54 SBL13 SBLB13 CS2 VSS sram_colmux
X361_colmux BL55 BLB55 SBL13 SBLB13 CS3 VSS sram_colmux
X362_colmux BL56 BLB56 SBL14 SBLB14 CS0 VSS sram_colmux
X363_colmux BL57 BLB57 SBL14 SBLB14 CS1 VSS sram_colmux
X364_colmux BL58 BLB58 SBL14 SBLB14 CS2 VSS sram_colmux
X365_colmux BL59 BLB59 SBL14 SBLB14 CS3 VSS sram_colmux
X366_colmux BL60 BLB60 SBL15 SBLB15 CS0 VSS sram_colmux
X367_colmux BL61 BLB61 SBL15 SBLB15 CS1 VSS sram_colmux
X368_colmux BL62 BLB62 SBL15 SBLB15 CS2 VSS sram_colmux
X369_colmux BL63 BLB63 SBL15 SBLB15 CS3 VSS sram_colmux
X370_colmux BL64 BLB64 SBL16 SBLB16 CS0 VSS sram_colmux
X371_colmux BL65 BLB65 SBL16 SBLB16 CS1 VSS sram_colmux
X372_colmux BL66 BLB66 SBL16 SBLB16 CS2 VSS sram_colmux
X373_colmux BL67 BLB67 SBL16 SBLB16 CS3 VSS sram_colmux
X374_colmux BL68 BLB68 SBL17 SBLB17 CS0 VSS sram_colmux
X375_colmux BL69 BLB69 SBL17 SBLB17 CS1 VSS sram_colmux
X376_colmux BL70 BLB70 SBL17 SBLB17 CS2 VSS sram_colmux
X377_colmux BL71 BLB71 SBL17 SBLB17 CS3 VSS sram_colmux
X378_colmux BL72 BLB72 SBL18 SBLB18 CS0 VSS sram_colmux
X379_colmux BL73 BLB73 SBL18 SBLB18 CS1 VSS sram_colmux
X380_colmux BL74 BLB74 SBL18 SBLB18 CS2 VSS sram_colmux
X381_colmux BL75 BLB75 SBL18 SBLB18 CS3 VSS sram_colmux
X382_colmux BL76 BLB76 SBL19 SBLB19 CS0 VSS sram_colmux
X383_colmux BL77 BLB77 SBL19 SBLB19 CS1 VSS sram_colmux
X384_colmux BL78 BLB78 SBL19 SBLB19 CS2 VSS sram_colmux
X385_colmux BL79 BLB79 SBL19 SBLB19 CS3 VSS sram_colmux
X386_colmux BL80 BLB80 SBL20 SBLB20 CS0 VSS sram_colmux
X387_colmux BL81 BLB81 SBL20 SBLB20 CS1 VSS sram_colmux
X388_colmux BL82 BLB82 SBL20 SBLB20 CS2 VSS sram_colmux
X389_colmux BL83 BLB83 SBL20 SBLB20 CS3 VSS sram_colmux
X390_colmux BL84 BLB84 SBL21 SBLB21 CS0 VSS sram_colmux
X391_colmux BL85 BLB85 SBL21 SBLB21 CS1 VSS sram_colmux
X392_colmux BL86 BLB86 SBL21 SBLB21 CS2 VSS sram_colmux
X393_colmux BL87 BLB87 SBL21 SBLB21 CS3 VSS sram_colmux
X394_colmux BL88 BLB88 SBL22 SBLB22 CS0 VSS sram_colmux
X395_colmux BL89 BLB89 SBL22 SBLB22 CS1 VSS sram_colmux
X396_colmux BL90 BLB90 SBL22 SBLB22 CS2 VSS sram_colmux
X397_colmux BL91 BLB91 SBL22 SBLB22 CS3 VSS sram_colmux
X398_colmux BL92 BLB92 SBL23 SBLB23 CS0 VSS sram_colmux
X399_colmux BL93 BLB93 SBL23 SBLB23 CS1 VSS sram_colmux
X400_colmux BL94 BLB94 SBL23 SBLB23 CS2 VSS sram_colmux
X401_colmux BL95 BLB95 SBL23 SBLB23 CS3 VSS sram_colmux
X402_colmux BL96 BLB96 SBL24 SBLB24 CS0 VSS sram_colmux
X403_colmux BL97 BLB97 SBL24 SBLB24 CS1 VSS sram_colmux
X404_colmux BL98 BLB98 SBL24 SBLB24 CS2 VSS sram_colmux
X405_colmux BL99 BLB99 SBL24 SBLB24 CS3 VSS sram_colmux
X406_colmux BL100 BLB100 SBL25 SBLB25 CS0 VSS sram_colmux
X407_colmux BL101 BLB101 SBL25 SBLB25 CS1 VSS sram_colmux
X408_colmux BL102 BLB102 SBL25 SBLB25 CS2 VSS sram_colmux
X409_colmux BL103 BLB103 SBL25 SBLB25 CS3 VSS sram_colmux
X410_colmux BL104 BLB104 SBL26 SBLB26 CS0 VSS sram_colmux
X411_colmux BL105 BLB105 SBL26 SBLB26 CS1 VSS sram_colmux
X412_colmux BL106 BLB106 SBL26 SBLB26 CS2 VSS sram_colmux
X413_colmux BL107 BLB107 SBL26 SBLB26 CS3 VSS sram_colmux
X414_colmux BL108 BLB108 SBL27 SBLB27 CS0 VSS sram_colmux
X415_colmux BL109 BLB109 SBL27 SBLB27 CS1 VSS sram_colmux
X416_colmux BL110 BLB110 SBL27 SBLB27 CS2 VSS sram_colmux
X417_colmux BL111 BLB111 SBL27 SBLB27 CS3 VSS sram_colmux
X418_colmux BL112 BLB112 SBL28 SBLB28 CS0 VSS sram_colmux
X419_colmux BL113 BLB113 SBL28 SBLB28 CS1 VSS sram_colmux
X420_colmux BL114 BLB114 SBL28 SBLB28 CS2 VSS sram_colmux
X421_colmux BL115 BLB115 SBL28 SBLB28 CS3 VSS sram_colmux
X422_colmux BL116 BLB116 SBL29 SBLB29 CS0 VSS sram_colmux
X423_colmux BL117 BLB117 SBL29 SBLB29 CS1 VSS sram_colmux
X424_colmux BL118 BLB118 SBL29 SBLB29 CS2 VSS sram_colmux
X425_colmux BL119 BLB119 SBL29 SBLB29 CS3 VSS sram_colmux
X426_colmux BL120 BLB120 SBL30 SBLB30 CS0 VSS sram_colmux
X427_colmux BL121 BLB121 SBL30 SBLB30 CS1 VSS sram_colmux
X428_colmux BL122 BLB122 SBL30 SBLB30 CS2 VSS sram_colmux
X429_colmux BL123 BLB123 SBL30 SBLB30 CS3 VSS sram_colmux
X430_colmux BL124 BLB124 SBL31 SBLB31 CS0 VSS sram_colmux
X431_colmux BL125 BLB125 SBL31 SBLB31 CS1 VSS sram_colmux
X432_colmux BL126 BLB126 SBL31 SBLB31 CS2 VSS sram_colmux
X433_colmux BL127 BLB127 SBL31 SBLB31 CS3 VSS sram_colmux
X434_senseamp SBL0 SBLB0 SAE SAEB Q0 VDD VSS sram_senseamp
X435_wdrv SBL0 SBLB0 D0 WEN VDD VSS sram_wdrv
X436_senseamp SBL1 SBLB1 SAE SAEB Q1 VDD VSS sram_senseamp
X437_wdrv SBL1 SBLB1 D1 WEN VDD VSS sram_wdrv
X438_senseamp SBL2 SBLB2 SAE SAEB Q2 VDD VSS sram_senseamp
X439_wdrv SBL2 SBLB2 D2 WEN VDD VSS sram_wdrv
X440_senseamp SBL3 SBLB3 SAE SAEB Q3 VDD VSS sram_senseamp
X441_wdrv SBL3 SBLB3 D3 WEN VDD VSS sram_wdrv
X442_senseamp SBL4 SBLB4 SAE SAEB Q4 VDD VSS sram_senseamp
X443_wdrv SBL4 SBLB4 D4 WEN VDD VSS sram_wdrv
X444_senseamp SBL5 SBLB5 SAE SAEB Q5 VDD VSS sram_senseamp
X445_wdrv SBL5 SBLB5 D5 WEN VDD VSS sram_wdrv
X446_senseamp SBL6 SBLB6 SAE SAEB Q6 VDD VSS sram_senseamp
X447_wdrv SBL6 SBLB6 D6 WEN VDD VSS sram_wdrv
X448_senseamp SBL7 SBLB7 SAE SAEB Q7 VDD VSS sram_senseamp
X449_wdrv SBL7 SBLB7 D7 WEN VDD VSS sram_wdrv
X450_senseamp SBL8 SBLB8 SAE SAEB Q8 VDD VSS sram_senseamp
X451_wdrv SBL8 SBLB8 D8 WEN VDD VSS sram_wdrv
X452_senseamp SBL9 SBLB9 SAE SAEB Q9 VDD VSS sram_senseamp
X453_wdrv SBL9 SBLB9 D9 WEN VDD VSS sram_wdrv
X454_senseamp SBL10 SBLB10 SAE SAEB Q10 VDD VSS sram_senseamp
X455_wdrv SBL10 SBLB10 D10 WEN VDD VSS sram_wdrv
X456_senseamp SBL11 SBLB11 SAE SAEB Q11 VDD VSS sram_senseamp
X457_wdrv SBL11 SBLB11 D11 WEN VDD VSS sram_wdrv
X458_senseamp SBL12 SBLB12 SAE SAEB Q12 VDD VSS sram_senseamp
X459_wdrv SBL12 SBLB12 D12 WEN VDD VSS sram_wdrv
X460_senseamp SBL13 SBLB13 SAE SAEB Q13 VDD VSS sram_senseamp
X461_wdrv SBL13 SBLB13 D13 WEN VDD VSS sram_wdrv
X462_senseamp SBL14 SBLB14 SAE SAEB Q14 VDD VSS sram_senseamp
X463_wdrv SBL14 SBLB14 D14 WEN VDD VSS sram_wdrv
X464_senseamp SBL15 SBLB15 SAE SAEB Q15 VDD VSS sram_senseamp
X465_wdrv SBL15 SBLB15 D15 WEN VDD VSS sram_wdrv
X466_senseamp SBL16 SBLB16 SAE SAEB Q16 VDD VSS sram_senseamp
X467_wdrv SBL16 SBLB16 D16 WEN VDD VSS sram_wdrv
X468_senseamp SBL17 SBLB17 SAE SAEB Q17 VDD VSS sram_senseamp
X469_wdrv SBL17 SBLB17 D17 WEN VDD VSS sram_wdrv
X470_senseamp SBL18 SBLB18 SAE SAEB Q18 VDD VSS sram_senseamp
X471_wdrv SBL18 SBLB18 D18 WEN VDD VSS sram_wdrv
X472_senseamp SBL19 SBLB19 SAE SAEB Q19 VDD VSS sram_senseamp
X473_wdrv SBL19 SBLB19 D19 WEN VDD VSS sram_wdrv
X474_senseamp SBL20 SBLB20 SAE SAEB Q20 VDD VSS sram_senseamp
X475_wdrv SBL20 SBLB20 D20 WEN VDD VSS sram_wdrv
X476_senseamp SBL21 SBLB21 SAE SAEB Q21 VDD VSS sram_senseamp
X477_wdrv SBL21 SBLB21 D21 WEN VDD VSS sram_wdrv
X478_senseamp SBL22 SBLB22 SAE SAEB Q22 VDD VSS sram_senseamp
X479_wdrv SBL22 SBLB22 D22 WEN VDD VSS sram_wdrv
X480_senseamp SBL23 SBLB23 SAE SAEB Q23 VDD VSS sram_senseamp
X481_wdrv SBL23 SBLB23 D23 WEN VDD VSS sram_wdrv
X482_senseamp SBL24 SBLB24 SAE SAEB Q24 VDD VSS sram_senseamp
X483_wdrv SBL24 SBLB24 D24 WEN VDD VSS sram_wdrv
X484_senseamp SBL25 SBLB25 SAE SAEB Q25 VDD VSS sram_senseamp
X485_wdrv SBL25 SBLB25 D25 WEN VDD VSS sram_wdrv
X486_senseamp SBL26 SBLB26 SAE SAEB Q26 VDD VSS sram_senseamp
X487_wdrv SBL26 SBLB26 D26 WEN VDD VSS sram_wdrv
X488_senseamp SBL27 SBLB27 SAE SAEB Q27 VDD VSS sram_senseamp
X489_wdrv SBL27 SBLB27 D27 WEN VDD VSS sram_wdrv
X490_senseamp SBL28 SBLB28 SAE SAEB Q28 VDD VSS sram_senseamp
X491_wdrv SBL28 SBLB28 D28 WEN VDD VSS sram_wdrv
X492_senseamp SBL29 SBLB29 SAE SAEB Q29 VDD VSS sram_senseamp
X493_wdrv SBL29 SBLB29 D29 WEN VDD VSS sram_wdrv
X494_senseamp SBL30 SBLB30 SAE SAEB Q30 VDD VSS sram_senseamp
X495_wdrv SBL30 SBLB30 D30 WEN VDD VSS sram_wdrv
X496_senseamp SBL31 SBLB31 SAE SAEB Q31 VDD VSS sram_senseamp
X497_wdrv SBL31 SBLB31 D31 WEN VDD VSS sram_wdrv
.ends
