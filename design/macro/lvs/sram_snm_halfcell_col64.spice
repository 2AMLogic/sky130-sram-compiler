** SNM half-cell column top: LVS reference for gen_layout.py --snm-halfcell
** generated by design/macro/lvs/make_snm_ref.py from the committed macro netlist; do not edit by hand
.subckt bitcell_6t BL BLB WL VDD VSS
*.iopin BL
*.iopin BLB
*.iopin WL
*.iopin VDD
*.iopin VSS
XMPL Q QB VDD VDD sky130_fd_pr__pfet_01v8 L=0.15 W=0.42 nf=1 ad=0.1218 as=0.1218 pd=1.42 ps=1.42 nrd=0.6905 nrs=0.6905 sa=0 sb=0 sd=0 mult=1 m=1
XMPR QB Q VDD VDD sky130_fd_pr__pfet_01v8 L=0.15 W=0.42 nf=1 ad=0.1218 as=0.1218 pd=1.42 ps=1.42 nrd=0.6905 nrs=0.6905 sa=0 sb=0 sd=0 mult=1 m=1
XMNL Q QB VSS VSS sky130_fd_pr__nfet_01v8 L=0.15 W=0.84 nf=1 ad=0.2436 as=0.2436 pd=2.26 ps=2.26 nrd=0.3452 nrs=0.3452 sa=0 sb=0 sd=0 mult=1 m=1
XMNR QB Q VSS VSS sky130_fd_pr__nfet_01v8 L=0.15 W=0.84 nf=1 ad=0.2436 as=0.2436 pd=2.26 ps=2.26 nrd=0.3452 nrs=0.3452 sa=0 sb=0 sd=0 mult=1 m=1
XMAL BL WL Q VSS sky130_fd_pr__nfet_01v8 L=0.15 W=0.42 nf=1 ad=0.1218 as=0.1218 pd=1.42 ps=1.42 nrd=0.6905 nrs=0.6905 sa=0 sb=0 sd=0 mult=1 m=1
XMAR BLB WL QB VSS sky130_fd_pr__nfet_01v8 L=0.15 W=0.42 nf=1 ad=0.1218 as=0.1218 pd=1.42 ps=1.42 nrd=0.6905 nrs=0.6905 sa=0 sb=0 sd=0 mult=1 m=1
.ends
.subckt sram_precharge BL BLB PCHB VDD
*.iopin BL
*.iopin BLB
*.iopin PCHB
*.iopin VDD
XMP1 BL PCHB VDD VDD sky130_fd_pr__pfet_01v8 L=0.15 W=0.84 nf=1 ad=0.2436 as=0.2436 pd=2.26 ps=2.26 nrd=0.3452 nrs=0.3452 sa=0 sb=0 sd=0 mult=1 m=1
XMP2 BLB PCHB VDD VDD sky130_fd_pr__pfet_01v8 L=0.15 W=0.84 nf=1 ad=0.2436 as=0.2436 pd=2.26 ps=2.26 nrd=0.3452 nrs=0.3452 sa=0 sb=0 sd=0 mult=1 m=1
XMEQ BL PCHB BLB VDD sky130_fd_pr__pfet_01v8 L=0.15 W=0.42 nf=1 ad=0.1218 as=0.1218 pd=1.42 ps=1.42 nrd=0.6905 nrs=0.6905 sa=0 sb=0 sd=0 mult=1 m=1
.ends
.subckt snm_halfcell BL WL IN OUT VDD VSS
*.iopin BL
*.iopin WL
*.iopin IN
*.iopin OUT
*.iopin VDD
*.iopin VSS
XMPL OUT IN VDD VDD sky130_fd_pr__pfet_01v8 L=0.15 W=0.42 nf=1 ad=0.1218 as=0.1218 pd=1.42 ps=1.42 nrd=0.6905 nrs=0.6905 sa=0 sb=0 sd=0 mult=1 m=1
XMNL OUT IN VSS VSS sky130_fd_pr__nfet_01v8 L=0.15 W=0.84 nf=1 ad=0.2436 as=0.2436 pd=2.26 ps=2.26 nrd=0.3452 nrs=0.3452 sa=0 sb=0 sd=0 mult=1 m=1
XMAL BL WL OUT VSS sky130_fd_pr__nfet_01v8 L=0.15 W=0.42 nf=1 ad=0.1218 as=0.1218 pd=1.42 ps=1.42 nrd=0.6905 nrs=0.6905 sa=0 sb=0 sd=0 mult=1 m=1
.ends
.subckt sram_snm_halfcell_col64 BL0 BLB0 IN OUT PCHB VDD VSS WL0 WL1 WL2 WL3 WL4 WL5 WL6 WL7 WL8 WL9 WL10 WL11 WL12 WL13 WL14 WL15 WL16 WL17 WL18 WL19 WL20 WL21 WL22 WL23 WL24 WL25 WL26 WL27 WL28 WL29 WL30 WL31 WL32 WL33 WL34 WL35 WL36 WL37 WL38 WL39 WL40 WL41 WL42 WL43 WL44 WL45 WL46 WL47 WL48 WL49 WL50 WL51 WL52 WL53 WL54 WL55 WL56 WL57 WL58 WL59 WL60 WL61 WL62 WL63
XH0_0 BL0 WL0 IN OUT VDD VSS snm_halfcell
XC1_0 BL0 BLB0 WL1 VDD VSS bitcell_6t
XC2_0 BL0 BLB0 WL2 VDD VSS bitcell_6t
XC3_0 BL0 BLB0 WL3 VDD VSS bitcell_6t
XC4_0 BL0 BLB0 WL4 VDD VSS bitcell_6t
XC5_0 BL0 BLB0 WL5 VDD VSS bitcell_6t
XC6_0 BL0 BLB0 WL6 VDD VSS bitcell_6t
XC7_0 BL0 BLB0 WL7 VDD VSS bitcell_6t
XC8_0 BL0 BLB0 WL8 VDD VSS bitcell_6t
XC9_0 BL0 BLB0 WL9 VDD VSS bitcell_6t
XC10_0 BL0 BLB0 WL10 VDD VSS bitcell_6t
XC11_0 BL0 BLB0 WL11 VDD VSS bitcell_6t
XC12_0 BL0 BLB0 WL12 VDD VSS bitcell_6t
XC13_0 BL0 BLB0 WL13 VDD VSS bitcell_6t
XC14_0 BL0 BLB0 WL14 VDD VSS bitcell_6t
XC15_0 BL0 BLB0 WL15 VDD VSS bitcell_6t
XC16_0 BL0 BLB0 WL16 VDD VSS bitcell_6t
XC17_0 BL0 BLB0 WL17 VDD VSS bitcell_6t
XC18_0 BL0 BLB0 WL18 VDD VSS bitcell_6t
XC19_0 BL0 BLB0 WL19 VDD VSS bitcell_6t
XC20_0 BL0 BLB0 WL20 VDD VSS bitcell_6t
XC21_0 BL0 BLB0 WL21 VDD VSS bitcell_6t
XC22_0 BL0 BLB0 WL22 VDD VSS bitcell_6t
XC23_0 BL0 BLB0 WL23 VDD VSS bitcell_6t
XC24_0 BL0 BLB0 WL24 VDD VSS bitcell_6t
XC25_0 BL0 BLB0 WL25 VDD VSS bitcell_6t
XC26_0 BL0 BLB0 WL26 VDD VSS bitcell_6t
XC27_0 BL0 BLB0 WL27 VDD VSS bitcell_6t
XC28_0 BL0 BLB0 WL28 VDD VSS bitcell_6t
XC29_0 BL0 BLB0 WL29 VDD VSS bitcell_6t
XC30_0 BL0 BLB0 WL30 VDD VSS bitcell_6t
XC31_0 BL0 BLB0 WL31 VDD VSS bitcell_6t
XC32_0 BL0 BLB0 WL32 VDD VSS bitcell_6t
XC33_0 BL0 BLB0 WL33 VDD VSS bitcell_6t
XC34_0 BL0 BLB0 WL34 VDD VSS bitcell_6t
XC35_0 BL0 BLB0 WL35 VDD VSS bitcell_6t
XC36_0 BL0 BLB0 WL36 VDD VSS bitcell_6t
XC37_0 BL0 BLB0 WL37 VDD VSS bitcell_6t
XC38_0 BL0 BLB0 WL38 VDD VSS bitcell_6t
XC39_0 BL0 BLB0 WL39 VDD VSS bitcell_6t
XC40_0 BL0 BLB0 WL40 VDD VSS bitcell_6t
XC41_0 BL0 BLB0 WL41 VDD VSS bitcell_6t
XC42_0 BL0 BLB0 WL42 VDD VSS bitcell_6t
XC43_0 BL0 BLB0 WL43 VDD VSS bitcell_6t
XC44_0 BL0 BLB0 WL44 VDD VSS bitcell_6t
XC45_0 BL0 BLB0 WL45 VDD VSS bitcell_6t
XC46_0 BL0 BLB0 WL46 VDD VSS bitcell_6t
XC47_0 BL0 BLB0 WL47 VDD VSS bitcell_6t
XC48_0 BL0 BLB0 WL48 VDD VSS bitcell_6t
XC49_0 BL0 BLB0 WL49 VDD VSS bitcell_6t
XC50_0 BL0 BLB0 WL50 VDD VSS bitcell_6t
XC51_0 BL0 BLB0 WL51 VDD VSS bitcell_6t
XC52_0 BL0 BLB0 WL52 VDD VSS bitcell_6t
XC53_0 BL0 BLB0 WL53 VDD VSS bitcell_6t
XC54_0 BL0 BLB0 WL54 VDD VSS bitcell_6t
XC55_0 BL0 BLB0 WL55 VDD VSS bitcell_6t
XC56_0 BL0 BLB0 WL56 VDD VSS bitcell_6t
XC57_0 BL0 BLB0 WL57 VDD VSS bitcell_6t
XC58_0 BL0 BLB0 WL58 VDD VSS bitcell_6t
XC59_0 BL0 BLB0 WL59 VDD VSS bitcell_6t
XC60_0 BL0 BLB0 WL60 VDD VSS bitcell_6t
XC61_0 BL0 BLB0 WL61 VDD VSS bitcell_6t
XC62_0 BL0 BLB0 WL62 VDD VSS bitcell_6t
XC63_0 BL0 BLB0 WL63 VDD VSS bitcell_6t
XPCH0 BL0 BLB0 PCHB VDD sram_precharge
.ends
